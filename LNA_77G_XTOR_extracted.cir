* Extracted by KLayout with SG13G2 LVS runset on : 31/07/2026 17:39

.SUBCKT LNA_77G_XTOR
Q$1 GND GND \$74 \$1 npn13G2l we=70n le=1000n Nx=1 m=1
Q$2 \$171 NET1$1 \$36 \$1 npn13G2l we=70n le=1000n Nx=1 m=1
Q$3 \$173 \$174 \$36 \$1 npn13G2l we=70n le=1000n Nx=1 m=1
Q$4 \$171 NET1$1 \$36 \$1 npn13G2l we=70n le=1000n Nx=1 m=1
Q$5 \$173 \$174 \$36 \$1 npn13G2l we=70n le=1000n Nx=1 m=1
Q$6 \$171 NET1$1 \$36 \$1 npn13G2l we=70n le=1000n Nx=1 m=1
Q$7 \$173 \$174 \$36 \$1 npn13G2l we=70n le=1000n Nx=1 m=1
Q$8 \$171 NET1$1 \$36 \$1 npn13G2l we=70n le=1000n Nx=1 m=1
Q$9 \$173 \$174 \$36 \$1 npn13G2l we=70n le=1000n Nx=1 m=1
Q$10 \$240 B35&36 \$171 \$1 npn13G2l we=70n le=1000n Nx=1 m=1
Q$11 \$241 B35&36 \$173 \$1 npn13G2l we=70n le=1000n Nx=1 m=1
Q$12 \$240 B35&36 \$171 \$1 npn13G2l we=70n le=1000n Nx=1 m=1
Q$13 \$241 B35&36 \$173 \$1 npn13G2l we=70n le=1000n Nx=1 m=1
Q$14 \$240 B35&36 \$171 \$1 npn13G2l we=70n le=1000n Nx=1 m=1
Q$15 \$241 B35&36 \$173 \$1 npn13G2l we=70n le=1000n Nx=1 m=1
Q$16 \$240 B35&36 \$171 \$1 npn13G2l we=70n le=1000n Nx=1 m=1
Q$17 \$241 B35&36 \$173 \$1 npn13G2l we=70n le=1000n Nx=1 m=1
R$18 \$36 GND \$1 rppd w=7u l=38.8u ps=0u b=0 m=1
R$19 \$36 GND \$1 rppd w=7u l=38.8u ps=0u b=0 m=1
R$20 \$36 GND \$1 rppd w=7u l=38.8u ps=0u b=0 m=1
R$21 \$74 GND \$1 rppd w=2.5u l=10.53u ps=0u b=0 m=1
R$22 \$74 GND \$1 rppd w=2.5u l=10.53u ps=0u b=0 m=1
R$23 \$74 GND \$1 rppd w=2.5u l=10.53u ps=0u b=0 m=1
R$24 \$74 GND \$1 rppd w=2.5u l=10.53u ps=0u b=0 m=1
R$25 \$74 GND \$1 rppd w=2.5u l=10.53u ps=0u b=0 m=1
R$26 \$74 GND \$1 rppd w=2.5u l=10.53u ps=0u b=0 m=1
R$27 \$74 GND \$1 rppd w=2.5u l=10.53u ps=0u b=0 m=1
R$28 \$74 GND \$1 rppd w=2.5u l=10.53u ps=0u b=0 m=1
R$29 \$74 GND \$1 rppd w=2.5u l=10.53u ps=0u b=0 m=1
R$30 \$74 GND \$1 rppd w=2.5u l=10.53u ps=0u b=0 m=1
R$31 \$74 GND \$1 rppd w=2.5u l=10.53u ps=0u b=0 m=1
R$32 \$74 GND \$1 rppd w=2.5u l=10.53u ps=0u b=0 m=1
R$33 \$74 GND \$1 rppd w=2.5u l=10.53u ps=0u b=0 m=1
R$34 2V4$1 B35&36 \$1 rppd w=3u l=18.23u ps=0u b=0 m=1
R$35 2V4$1 B35&36 \$1 rppd w=3u l=18.23u ps=0u b=0 m=1
R$36 B35&36 GND \$1 rppd w=3u l=18.23u ps=0u b=0 m=1
R$37 GND GND \$1 rppd w=3u l=18.23u ps=0u b=0 m=1
R$38 GND GND \$1 rppd w=3u l=18.23u ps=0u b=0 m=1
C$39 NET1 INP cap_cmim w=6.99u l=6.99u A=48.8601p P=27.96u m=1
C$40 OUTP \$240 cap_cmim w=6.99u l=6.99u A=48.8601p P=27.96u m=1
C$41 BYP4 GND cap_cmim w=6.99u l=6.99u A=48.8601p P=27.96u m=1
C$42 BYP3 \$53 cap_cmim w=6.99u l=6.99u A=48.8601p P=27.96u m=1
C$43 2V4 \$241 cap_cmim w=6.99u l=6.99u A=48.8601p P=27.96u m=1
C$44 BYP2 \$51 cap_cmim w=6.99u l=6.99u A=48.8601p P=27.96u m=1
C$45 GND$1 \$174 cap_cmim w=6.99u l=6.99u A=48.8601p P=27.96u m=1
C$46 2V4|BYP1 \$35 cap_cmim w=6.99u l=6.99u A=48.8601p P=27.96u m=1
C$47 2V4|BYP1 \$14 cap_cmim w=6.99u l=6.99u A=48.8601p P=27.96u m=1
.ENDS LNA_77G_XTOR
