* Extracted by KLayout with SG13G2 LVS runset on : 05/08/2026 11:16

.SUBCKT LNA_77G_XTOR
Q$1 GND GND \$72 \$1 npn13G2l we=70n le=1000n Nx=1 m=1
Q$2 \$169 NET1$1 \$36 \$1 npn13G2l we=70n le=1000n Nx=1 m=1
Q$3 \$170 \$171 \$36 \$1 npn13G2l we=70n le=1000n Nx=1 m=1
Q$4 \$169 NET1$1 \$36 \$1 npn13G2l we=70n le=1000n Nx=1 m=1
Q$5 \$170 \$171 \$36 \$1 npn13G2l we=70n le=1000n Nx=1 m=1
Q$6 \$169 NET1$1 \$36 \$1 npn13G2l we=70n le=1000n Nx=1 m=1
Q$7 \$170 \$171 \$36 \$1 npn13G2l we=70n le=1000n Nx=1 m=1
Q$8 \$169 NET1$1 \$36 \$1 npn13G2l we=70n le=1000n Nx=1 m=1
Q$9 \$170 \$171 \$36 \$1 npn13G2l we=70n le=1000n Nx=1 m=1
Q$10 \$237 B35&36 \$169 \$1 npn13G2l we=70n le=1000n Nx=1 m=1
Q$11 \$238 B35&36 \$170 \$1 npn13G2l we=70n le=1000n Nx=1 m=1
Q$12 \$237 B35&36 \$169 \$1 npn13G2l we=70n le=1000n Nx=1 m=1
Q$13 \$238 B35&36 \$170 \$1 npn13G2l we=70n le=1000n Nx=1 m=1
Q$14 \$237 B35&36 \$169 \$1 npn13G2l we=70n le=1000n Nx=1 m=1
Q$15 \$238 B35&36 \$170 \$1 npn13G2l we=70n le=1000n Nx=1 m=1
Q$16 \$237 B35&36 \$169 \$1 npn13G2l we=70n le=1000n Nx=1 m=1
Q$17 \$238 B35&36 \$170 \$1 npn13G2l we=70n le=1000n Nx=1 m=1
R$18 \$36 GND \$1 rppd w=7u l=38.8u ps=0u b=0 m=1
R$19 \$36 GND \$1 rppd w=7u l=38.8u ps=0u b=0 m=1
R$20 \$36 GND \$1 rppd w=7u l=38.8u ps=0u b=0 m=1
R$21 \$72 GND \$1 rppd w=2.5u l=10.53u ps=0u b=0 m=1
R$22 \$72 GND \$1 rppd w=2.5u l=10.53u ps=0u b=0 m=1
R$23 \$72 GND \$1 rppd w=2.5u l=10.53u ps=0u b=0 m=1
R$24 \$72 GND \$1 rppd w=2.5u l=10.53u ps=0u b=0 m=1
R$25 \$72 GND \$1 rppd w=2.5u l=10.53u ps=0u b=0 m=1
R$26 \$72 GND \$1 rppd w=2.5u l=10.53u ps=0u b=0 m=1
R$27 \$72 GND \$1 rppd w=2.5u l=10.53u ps=0u b=0 m=1
R$28 \$72 GND \$1 rppd w=2.5u l=10.53u ps=0u b=0 m=1
R$29 \$72 GND \$1 rppd w=2.5u l=10.53u ps=0u b=0 m=1
R$30 \$72 GND \$1 rppd w=2.5u l=10.53u ps=0u b=0 m=1
R$31 \$72 GND \$1 rppd w=2.5u l=10.53u ps=0u b=0 m=1
R$32 \$72 GND \$1 rppd w=2.5u l=10.53u ps=0u b=0 m=1
R$33 \$72 GND \$1 rppd w=2.5u l=10.53u ps=0u b=0 m=1
R$34 2V4$2 B35&36 \$1 rppd w=3u l=18.23u ps=0u b=0 m=1
R$35 2V4$2 B35&36 \$1 rppd w=3u l=18.23u ps=0u b=0 m=1
R$36 B35&36 GND \$1 rppd w=3u l=18.23u ps=0u b=0 m=1
R$37 GND GND \$1 rppd w=3u l=18.23u ps=0u b=0 m=1
R$38 GND GND \$1 rppd w=3u l=18.23u ps=0u b=0 m=1
C$39 NET1 INP cap_cmim w=6.99u l=6.99u A=48.8601p P=27.96u m=1
C$40 OUTP \$237 cap_cmim w=6.99u l=6.99u A=48.8601p P=27.96u m=1
C$41 BYP4$1 GND cap_cmim w=6.99u l=6.99u A=48.8601p P=27.96u m=1
C$42 BYP3$1 BYP4 cap_cmim w=6.99u l=6.99u A=48.8601p P=27.96u m=1
C$43 2V4$1 \$238 cap_cmim w=6.99u l=6.99u A=48.8601p P=27.96u m=1
C$44 BYP2$1 BYP3 cap_cmim w=6.99u l=6.99u A=48.8601p P=27.96u m=1
C$45 GND$1 \$171 cap_cmim w=6.99u l=6.99u A=48.8601p P=27.96u m=1
C$46 BYP1$1 BYP2 cap_cmim w=6.99u l=6.99u A=48.8601p P=27.96u m=1
C$47 2V4 BYP1 cap_cmim w=6.99u l=6.99u A=48.8601p P=27.96u m=1
.ENDS LNA_77G_XTOR
