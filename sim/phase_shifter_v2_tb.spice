* Phase Shifter V2 - Varactor-loaded transmission line
* IHP SG13G2 npn13G2l Cbc as tunable element

.LIB /home/bthomas3/Videos/IHP-Open-PDK/ihp-sg13g2/libs.tech/ngspice/models/cornerHBT.lib hbt_typ
.GLOBAL sub!
Vsub sub! 0 0

.param vctrl=1.0

* Transmission line approximation (lumped LC, lambda/8 at 77GHz)
* Z0=70 ohm -> L=Z0/(2*pi*f)=145pH, C=1/(Z0*2*pi*f)=29.5fF
L1p inp mid_p 145p
L1n inn mid_n 145p
L2p mid_p outp 145p
L2n mid_n outn 145p

* Varactors: npn13G2l as B-C diode varactor (4 total for diff pair)
* Collector=signal, Base=bias, Emitter=GND
XQV1 mid_p vbias GND sub! npn13G2l Nx=4 selft=0
XQV2 mid_n vbias GND sub! npn13G2l Nx=4 selft=0

* Bias network
Rbias vctrl_node vbias 10k
Vctrl vctrl_node 0 {vctrl}

* Source (50 ohm, differential)
Vp inp_src 0 DC 0 AC 1
Vn inn_src 0 DC 0 AC -1
Rs1 inp_src inp 50
Rs2 inn_src inn 50

* Load (50 ohm)
RL1 outp 0 50
RL2 outn 0 50

.options method=gear reltol=1e-3 abstol=1e-9 vntol=1e-5

.control
  foreach vval 0.0 0.3 0.6 0.9 1.2 1.5 1.8 2.1 2.4 2.7 3.0
    alterparam vctrl = $vval
    reset
    ac lin 1 77e9 77e9

    let vdiff_out = v(outp) - v(outn)
    let vdiff_in = v(inp) - v(inn)
    let phase_shift = 180/PI * (ph(vdiff_out) - ph(vdiff_in))
    let gain_db = db(vdiff_out/vdiff_in)

    echo "VCTRL=$vval  Phase={$&phase_shift} deg  Gain={$&gain_db} dB"

  end

.endc

.end
