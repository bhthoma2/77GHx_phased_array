** VCO PVT Corner Sweep — IHP SG13G2 PDK
** Sweeps: hbt_typ/bcs/wcs × -40°C/27°C/125°C × VCC=2.16/2.4/2.64
.control
pre_osdi /home/bthomas3/Videos/ngspice_pdk/install/lib/ngspice/r3_cmc.osdi
pre_osdi /home/bthomas3/Videos/ngspice_pdk/install/lib/ngspice/psp103_nqs.osdi
.endc

.param corner_cje=1.0 corner_cjc=1.0 corner_cjcp=1.0
.param corner_is=1.0 corner_ibei=1.0
.param corner_re=1.0 corner_rcx=1.0 corner_rbx=1.0 corner_tf=1.0
.param vcc_val=2.4 temp_val=27

.param vbic_cje=corner_cje vbic_cjc=corner_cjc vbic_cjcp=corner_cjcp
.param vbic_is=corner_is vbic_ibei=corner_ibei
.param vbic_re=corner_re vbic_rcx=corner_rcx vbic_rbx=corner_rbx
.param vbic_tf=corner_tf

.include /home/bthomas3/Videos/IHP-Open-PDK/ihp-sg13g2/libs.tech/ngspice/models/sg13g2_hbt_mod.lib
.lib /home/bthomas3/Videos/IHP-Open-PDK/ihp-sg13g2/libs.tech/ngspice/models/cornerRES.lib res_typ
.lib /home/bthomas3/Videos/IHP-Open-PDK/ihp-sg13g2/libs.tech/ngspice/models/cornerCAP.lib cap_typ

.subckt cap_cmim PLUS MINUS w=10e-6 l=10e-6 m=1
.param Ctot={1.5e-3*w*l*m}
C1 PLUS MINUS {Ctot}
.ends cap_cmim

** TL models
.subckt TL_85_105u IN OUT GND
C1 IN GND 0.805fF
R1 IN n1 0.582
L1 n1 n2 11.71pH
C2 n2 GND 1.61fF
R2 n2 n3 0.582
L2 n3 n4 11.71pH
C3 n4 GND 1.61fF
R3 n4 n5 0.582
L3 n5 n6 11.71pH
C4 n6 GND 1.61fF
R4 n6 n7 0.582
L4 n7 OUT 11.71pH
C5 OUT GND 0.805fF
.ends

.subckt TL_85_135u IN OUT GND
C1 IN GND 1.385fF
R1 IN n1 0.997
L1 n1 n2 20.07pH
C2 n2 GND 2.77fF
R2 n2 n3 0.997
L2 n3 n4 20.07pH
C3 n4 GND 2.77fF
R3 n4 n5 0.997
L3 n5 OUT 20.07pH
C4 OUT GND 1.385fF
.ends

** VCO
.subckt VCO_77G OUTP OUTN VTUNE VCC VSS
XQ1 OUTP OUTN net_tail VSS npn13G2l Nx=2 le=2.5e-6
XQ2 OUTN OUTP net_tail VSS npn13G2l Nx=2 le=2.5e-6
XTLRES1 OUTP res1_end VSS TL_85_135u
XTLRES2 OUTN res2_end VSS TL_85_135u
Cvar1 OUTP net_var1 3fF
Rvar1 net_var1 VTUNE 500
Cvar2 OUTN net_var2 3fF
Rvar2 net_var2 VTUNE 500
Rtail net_tail VSS 200
XTLCHK1 VCC OUTP VSS TL_85_105u
XTLCHK2 VCC OUTN VSS TL_85_105u
Cdecap VCC VSS 3pF
.ends VCO_77G

** Testbench
VCC VCC 0 {vcc_val}
VTUNE VTUNE 0 1.2
XVCO OUTP OUTN VTUNE VCC 0 VCO_77G
RL1 OUTP 0 500
RL2 OUTN 0 500
Ikick OUTP 0 PWL(0 0 1p 100u 10p 100u 11p 0)

.control
echo "==========================================="
echo "  VCO PVT CORNER ANALYSIS"
echo "==========================================="
echo ""

foreach corner_name typ bcs wcs
  if $corner_name = typ
    alterparam corner_cje = 1.0
    alterparam corner_cjc = 1.0
    alterparam corner_cjcp = 1.0
    alterparam corner_is = 1.0
    alterparam corner_ibei = 1.0
    alterparam corner_re = 1.0
    alterparam corner_rcx = 1.0
    alterparam corner_rbx = 1.0
    alterparam corner_tf = 1.0
  end
  if $corner_name = bcs
    alterparam corner_cje = 0.83
    alterparam corner_cjc = 0.87
    alterparam corner_cjcp = 0.89
    alterparam corner_is = 1.26
    alterparam corner_ibei = 0.67
    alterparam corner_re = 0.73
    alterparam corner_rcx = 0.79
    alterparam corner_rbx = 0.88
    alterparam corner_tf = 0.89
  end
  if $corner_name = wcs
    alterparam corner_cje = 1.17
    alterparam corner_cjc = 1.13
    alterparam corner_cjcp = 1.11
    alterparam corner_is = 0.74
    alterparam corner_ibei = 1.33
    alterparam corner_re = 1.27
    alterparam corner_rcx = 1.21
    alterparam corner_rbx = 1.12
    alterparam corner_tf = 1.11
  end

  foreach temp_c -40 27 125
    foreach vcc_v 2.16 2.4 2.64
      alterparam vcc_val = $vcc_v
      alterparam temp_val = $temp_c
      set temp = $temp_c
      reset
      tran 0.1p 5n 0 0.1p

      let vdiff = v(outp) - v(outn)
      meas tran vosc pp vdiff from=4n to=5n
      meas tran t1 when vdiff=0 rise=10
      meas tran t2 when vdiff=0 rise=11
      if t2 > t1
        let f = 1/(t2-t1)
        echo "$corner_name T=$temp_c VCC=$vcc_v : fosc = $&f Hz, swing = $&vosc V"
      else
        echo "$corner_name T=$temp_c VCC=$vcc_v : NO OSCILLATION"
      end
    end
  end
end

echo ""
echo "==========================================="
.endc
.end
