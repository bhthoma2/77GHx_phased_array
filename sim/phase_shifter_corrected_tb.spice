* Phase Shifter - Corrected pin assignment
* Base=RF node, Collector=VCTRL (controls Cbc), Emitter=GND
* 4-stage loaded line, Nx=3, IHP SG13G2

.LIB /home/bthomas3/Videos/IHP-Open-PDK/ihp-sg13g2/libs.tech/ngspice/models/cornerHBT.lib hbt_typ
.GLOBAL sub!
Vsub sub! 0 0

.param vctrl=1.5

* 4 T-section LC stages (Z0=50 ohm, lambda/16 at 77GHz)
* L_half = Z0/(4*pi*f) = 50/(4*pi*77e9) = 52pH

* Positive side
L1a inp n1 52p
L1b n1 n2 52p
L2a n2 n3 52p
L2b n3 n4 52p
L3a n4 n5 52p
L3b n5 n6 52p
L4a n6 n7 52p
L4b n7 outp 52p

* Negative side
L1an inn m1 52p
L1bn m1 m2 52p
L2an m2 m3 52p
L2bn m3 m4 52p
L3an m4 m5 52p
L3bn m5 m6 52p
L4an m6 m7 52p
L4bn m7 outn 52p

* Varactors: BASE=RF signal node, COLLECTOR=vbias(ctrl), EMITTER=GND
* npn13G2l pinout: X<name> collector base emitter substrate
* So: XQV1 vbias n1 GND sub! npn13G2l
XQV1 vbias n1 GND sub! npn13G2l Nx=3 selft=0
XQV2 vbias n3 GND sub! npn13G2l Nx=3 selft=0
XQV3 vbias n5 GND sub! npn13G2l Nx=3 selft=0
XQV4 vbias n7 GND sub! npn13G2l Nx=3 selft=0
XQV5 vbias m1 GND sub! npn13G2l Nx=3 selft=0
XQV6 vbias m3 GND sub! npn13G2l Nx=3 selft=0
XQV7 vbias m5 GND sub! npn13G2l Nx=3 selft=0
XQV8 vbias m7 GND sub! npn13G2l Nx=3 selft=0

* Bias: VCTRL -> collector through 10k (RF isolation)
Rbias vctrl_node vbias 10k
Cbias vbias GND 10p
Vctrl vctrl_node 0 {vctrl}

* Source (50 ohm differential)
Vp inp_src 0 DC 0 AC 1
Vn inn_src 0 DC 0 AC -1
Rs1 inp_src inp 50
Rs2 inn_src inn 50

* Load (50 ohm)
RL1 outp 0 50
RL2 outn 0 50

.options method=gear reltol=1e-3 abstol=1e-9 vntol=1e-5 itl1=500

.control
  foreach vval 0.0 0.3 0.6 0.9 1.2 1.5 1.8 2.1 2.4 2.7 3.0 3.3
    alterparam vctrl = $vval
    reset
    ac lin 1 77e9 77e9

    let vdiff_out = v(outp) - v(outn)
    let vdiff_in = v(inp) - v(inn)
    let phase_shift = 180/PI * (ph(vdiff_out) - ph(vdiff_in))
    let gain_db = db(vdiff_out/vdiff_in)

    echo "VCTRL=$vval  Phase=$&phase_shift deg  Gain=$&gain_db dB"
  end
.endc

.end
