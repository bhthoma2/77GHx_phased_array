** 77 GHz LNA — FULL IHP SG13G2 PDK (ngspice-46 + OSDI)
.control
pre_osdi /home/bthomas3/Videos/ngspice_pdk/install/lib/ngspice/r3_cmc.osdi
pre_osdi /home/bthomas3/Videos/ngspice_pdk/install/lib/ngspice/psp103_nqs.osdi
.endc

.lib /home/bthomas3/Videos/IHP-Open-PDK/ihp-sg13g2/libs.tech/ngspice/models/cornerHBT.lib hbt_typ
.lib /home/bthomas3/Videos/IHP-Open-PDK/ihp-sg13g2/libs.tech/ngspice/models/cornerRES.lib res_typ
.lib /home/bthomas3/Videos/IHP-Open-PDK/ihp-sg13g2/libs.tech/ngspice/models/cornerCAP.lib cap_typ

** === MIM Cap ===
.subckt cap_cmim PLUS MINUS w=10e-6 l=10e-6 m=1
.param Ctot={1.5e-3*w*l*m}
C1 PLUS MINUS {Ctot}
.ends cap_cmim

** === TL Models (Z0=85 Ohm, SG13G2 TM2) ===
.subckt TL_85_97u IN OUT GND
C1 IN GND 0.77fF
R1 IN n1 0.554
L1 n1 n2 11.15pH
C2 n2 GND 1.54fF
R2 n2 n3 0.554
L2 n3 n4 11.15pH
C3 n4 GND 1.54fF
R3 n4 n5 0.554
L3 n5 n6 11.15pH
C4 n6 GND 1.54fF
R4 n6 n7 0.554
L4 n7 OUT 11.15pH
C5 OUT GND 0.77fF
.ends

.subckt TL_85_151u IN OUT GND
* Lengthened to 210µm for 77 GHz peak (7 sections × 30µm)
* L_sec = 445.9e-9 * 30e-6 = 13.38pH
* C_sec = 61.5e-12 * 30e-6 = 1.845fF
* R_sec = 22.16e3 * 30e-6 = 0.665
C1 IN GND 0.92fF
R1 IN n1 0.665
L1 n1 n2 13.38pH
C2 n2 GND 1.845fF
R2 n2 n3 0.665
L2 n3 n4 13.38pH
C3 n4 GND 1.845fF
R3 n4 n5 0.665
L3 n5 n6 13.38pH
C4 n6 GND 1.845fF
R4 n6 n7 0.665
L4 n7 n8 13.38pH
C5 n8 GND 1.845fF
R5 n8 n9 0.665
L5 n9 n10 13.38pH
C6 n10 GND 1.845fF
R6 n10 n11 0.665
L6 n11 n12 13.38pH
C7 n12 GND 1.845fF
R7 n12 n13 0.665
L7 n13 OUT 13.38pH
C8 OUT GND 0.92fF
.ends

.subckt TL_85_58u IN OUT GND
C1 IN GND 0.89fF
R1 IN n1 0.643
L1 n1 n2 12.9pH
C2 n2 GND 1.79fF
R2 n2 n3 0.643
L2 n3 OUT 12.9pH
C3 OUT GND 0.89fF
.ends

** === LNA (Differential Cascode) ===
.subckt RXAMP_77GD INP INN OUTP OUTN VCC VSS

XQ1 net_c1 INP net_e1 VSS npn13G2l Nx=4 le=2.5e-6
XQ2 net_c2 INN net_e2 VSS npn13G2l Nx=4 le=2.5e-6
XQ3 OUTP VB1 net_c1 VSS npn13G2l Nx=4 le=2.5e-6
XQ4 OUTN VB1 net_c2 VSS npn13G2l Nx=4 le=2.5e-6

XTL_IN1 INP net_in1 VSS TL_85_97u
XTL_IN2 INN net_in2 VSS TL_85_97u
XTL_LOAD1 VCC OUTP VSS TL_85_151u
XTL_LOAD2 VCC OUTN VSS TL_85_151u
XTL_DEG1 net_e1 VSS VSS TL_85_58u
XTL_DEG2 net_e2 VSS VSS TL_85_58u

Cin1 net_in1 VSS 30fF
Cin2 net_in2 VSS 30fF

RB1 VCC VB1 2k
CB1 VB1 VSS 1pF

.ends RXAMP_77GD

** === Testbench ===
VCC VCC 0 2.4
VB_IN VB_IN 0 0.92

Cblock1 inp_ac INP 100fF
Cblock2 inn_ac INN 100fF
Rbias1 VB_IN INP 10k
Rbias2 VB_IN INN 10k

XLNA INP INN OUTP OUTN VCC 0 RXAMP_77GD

RL1 OUTP 0 200
RL2 OUTN 0 200

.control
** AC Analysis
ac dec 100 50G 110G

let gain_diff = vdb(outp) - vdb(outn)
let gain_se = vdb(outp)
meas ac gain_77g find vdb(outp) at=77G
meas ac gain_50g find vdb(outp) at=50G
meas ac gain_100g find vdb(outp) at=100G
meas ac bw_3db when vdb(outp)={gain_77g-3} fall=1

echo ""
echo "========================================="
echo "  LNA RESULTS — FULL IHP SG13G2 PDK"
echo "========================================="
echo "Gain at 77 GHz (SE):"
print gain_77g
echo "Gain at 50 GHz:"
print gain_50g
echo "Gain at 100 GHz:"
print gain_100g
echo "ICC:"
print @vcc[i]
echo "========================================="
echo ""

** Transient at 77 GHz
tran 0.1p 2n 0.5n 0.1p
meas tran vout_pp pp v(outp) from=1n to=2n
meas tran vin_pp pp v(inp_ac) from=1n to=2n
echo "Transient gain (Vout_pp/Vin_pp):"
let tgain = vout_pp/vin_pp
print tgain
.endc

Vrf inp_ac 0 DC 0 AC 1 SIN(0 10m 77G)
Vrfn inn_ac 0 DC 0 AC -1 SIN(0 -10m 77G)

.end
