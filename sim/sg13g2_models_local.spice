** IHP SG13G2 Device Models — Extracted for local ngspice (no OSDI)
** Source: IHP-Open-PDK/ihp-sg13g2/libs.tech/ngspice/models/sg13g2_hbt_mod.lib
** Modified: removed thermal node (t), use 4-terminal VBIC
** Resistors: use simple R (no r3_cmc Verilog-A needed)

** =====================================================================
** npn13G2l: High-speed SiGe HBT (fT~350GHz, fmax~450GHz)
** 4-terminal version: c b e bn (no thermal node)
** =====================================================================
.subckt npn13G2l c b e bn Nx=1 le=2.50e-6
.param El={le*1e6}
.param dtemp=0

Qnpn13G2l c b e s1 npn13G2l_vbic m=1

.model npn13G2l_vbic npn level=4
+ tnom = 27
+ cbeo = {1.92E-15*(El/2.5)**0.85*(Nx*0.25)**0.95}
+ cje = {2.166E-14*(El/2.5)**0.85*(Nx*0.25)**0.95}
+ pe = 0.92
+ me = 0.12
+ aje = -0.50
+ wbe = 1.00
+ cbco = {6.33E-15*(El/2.5)**0.85*(Nx*0.25)**0.975}
+ cjc = {3.83E-15*(El/2.5)**0.85*(Nx*0.25)**0.975}
+ pc = 0.558
+ mc = 0.12
+ ajc = -0.50
+ cjep = {7.77E-15*(El/2.5)**0.85*(Nx*0.25)**0.975}
+ cjcp = {8.36E-15*(El/2.5)**0.55*(Nx*0.25)**0.8}
+ ps = 0.46
+ ms = 0.23
+ ajs = -0.50
+ fc = 0.80
+ vef = 189
+ ver = 5.3
+ is = {7.50E-17*(El/2.5)**0.85*(Nx*0.25)}
+ nf = 1.004
+ ibei = {2.01E-19*(El/2.5)**0.85*(Nx*0.25)}
+ nei = 1.035
+ iben = {1.20E-15*(El/2.5)**0.85*(Nx*0.25)}
+ nen = 2.00
+ ikf = {0.032*(El/2.5)*(Nx*0.25)}
+ nr = 1.01
+ ibci = {3.00E-19*(El/2.5)*(Nx*0.25)}
+ nci = 1.050
+ ibcn = {1.00E-15*(El/2.5)*(Nx*0.25)}
+ ncn = 1.70
+ ikr = {0.01*(El/2.5)*(Nx*0.25)}
+ wsp = 1
+ isp = {4.00E-20*(El/2.5)*(Nx*0.25)}
+ nfp = 1.04
+ ibcip = {2.00E-15*(El/2.5)*(Nx*0.25)**0.7}
+ ncip = 1.00
+ ibcnp = {5.00E-15*(El/2.5)*(Nx*0.25)}
+ ncnp = 1.50
+ ikp = {1.00E-04*(El/2.5)*(Nx*0.25)}
+ ibeip = {4.00E-19*(El/2.5)*(Nx*0.25)}
+ ibenp = {2.00E-14*(El/2.5)*(Nx*0.25)}
+ re = {3.19E+00*(2.5/El)*(4/Nx)**0.88}
+ rcx = {3.90E+00*(2.5/El)*(4/Nx)**0.9}
+ rci = {7.50E+00*(2.5/El)**0.85*(4/Nx)**1}
+ vo = 0.80
+ gamm = 3.00E-14
+ hrcf = 1000
+ rbx = {2.54E+00*(2.5/El)**0.7*(4/Nx)}
+ rbi = {7.26E+00*(2.5/El)**0.7*(4/Nx)}
+ rbp = {15.0*(2.5/El)**0.7*(4/Nx)}
+ rs = {1*(2.5/El)*(4/Nx)}
+ avc1 = 2.40
+ avc2 = 10.81
+ tf = {2.31E-13*(El/2.5)**0.15}
+ xtf = 10.0
+ vtf = 20.0
+ itf = {1.658*(El/2.5)*(Nx*0.25)}
+ tr = 5.00E-13

Rsub s1 bn {(300+(400*Nx))*(El/2.5)**0.5}
Csub s1 bn {(1.70E-14-(2.00E-15*Nx))*(El/2.5)}

.ends npn13G2l

** =====================================================================
** cap_cmim: MIM capacitor (1.5 fF/µm²)
** =====================================================================
.subckt cap_cmim PLUS MINUS w=10e-6 l=10e-6 m=1
.param Ctot={1.5e-3*w*l*m}
C1 PLUS MINUS {Ctot}
.ends cap_cmim

** =====================================================================
** rppd: P+ poly resistor (Rsh=260 Ω/sq typical)
** =====================================================================
.subckt rppd 1 2 bn w=3e-6 l=18e-6 b=0 m=1
.param Rtot={260*(l/w)/m}
R1 1 2 {Rtot}
.ends rppd

** =====================================================================
** rsil: Silicided resistor (Rsh=7 Ω/sq typical)
** =====================================================================
.subckt rsil 1 2 bn w=7e-6 l=38.8e-6 b=0 m=1
.param Rtot={7*(l/w)/m}
R1 1 2 {Rtot}
.ends rsil
