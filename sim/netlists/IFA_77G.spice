** sch_path: /home/bthomas3/Videos/77GHz_phased_array/xschem/blocks/IFA_77G.sch
**.subckt IFA_77G VCC INP INN GND sub! OUTP OUTN
*.iopin INP
*.iopin INN
*.iopin OUTP
*.iopin OUTN
*.iopin VCC
*.iopin GND
*.iopin sub!
XQ1 net3 INP net1 sub! npn13G2l Nx=2 El=2.5
XQ2 net4 INN net1 sub! npn13G2l Nx=2 El=2.5
XQ3 OUTP net3 net2 sub! npn13G2l Nx=2 El=2.5
XQ4 OUTN net4 net2 sub! npn13G2l Nx=2 El=2.5
RL1 VCC net3 500
RL2 VCC net4 500
RL3 VCC OUTP 500
RL4 VCC OUTN 500
ITAIL1 net1 GND DC 2m
ITAIL2 net2 GND DC 2m
**.ends
.end
