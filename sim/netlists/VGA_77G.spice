** sch_path: /home/bthomas3/Videos/77GHz_phased_array/xschem/blocks/VGA_77G.sch
**.subckt VGA_77G VCC INP INN VCTRL GND sub! OUTP OUTN
*.iopin INP
*.iopin INN
*.iopin OUTP
*.iopin OUTN
*.iopin VCTRL
*.iopin VCC
*.iopin GND
*.iopin sub!
XQ1 OUTP INP net1 sub! npn13G2l Nx=2 El=2.5
XQ2 OUTN INN net1 sub! npn13G2l Nx=2 El=2.5
XQtail net1 VCTRL net2 sub! npn13G2l Nx=4 El=2.5
RL1 VCC OUTP 500
RL2 VCC OUTN 500
RE net2 GND 10
**.ends
.end
