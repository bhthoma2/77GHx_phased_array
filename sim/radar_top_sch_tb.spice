* RADAR_TOP Full System - All blocks from xschem .sch netlists
* IHP SG13G2 PDK: npn13G2l (VBIC), sg13_lv_nmos/pmos (PSP NQS), rppd, rsil, cap_cmim
* Signal chain: LNA -> Mixer -> IFA -> VGA -> ADC

.LIB /home/bthomas3/Videos/IHP-Open-PDK/ihp-sg13g2/libs.tech/ngspice/models/cornerHBT.lib hbt_typ
.LIB /home/bthomas3/Videos/IHP-Open-PDK/ihp-sg13g2/libs.tech/ngspice/models/cornerMOSlv.lib mos_tt
.LIB /home/bthomas3/Videos/IHP-Open-PDK/ihp-sg13g2/libs.tech/ngspice/models/cornerRES.lib res_typ
.LIB /home/bthomas3/Videos/IHP-Open-PDK/ihp-sg13g2/libs.tech/ngspice/models/cornerCAP.lib cap_typ

.options method=gear reltol=1e-2 abstol=1e-8 vntol=1e-4 itl1=500 itl4=500 gmin=1e-11 trtol=7
.GLOBAL sub!

** ============================================================
** SUBCIRCUIT DEFINITIONS (from xschem batch netlist)
** ============================================================

** IFA (IFA_77G.sch): 2-stage diff pair, 44dB gain
.subckt IFA_77G VCC INP INN GND sub OUTP OUTN
XQ1 out1p INP tail1 sub npn13G2l Nx=2 selft=0
XQ2 out1n INN tail1 sub npn13G2l Nx=2 selft=0
XQ3 OUTP out1p tail2 sub npn13G2l Nx=2 selft=0
XQ4 OUTN out1n tail2 sub npn13G2l Nx=2 selft=0
RL1 VCC out1p 500
RL2 VCC out1n 500
RL3 VCC OUTP 500
RL4 VCC OUTN 500
ITAIL1 tail1 GND DC 2m
ITAIL2 tail2 GND DC 2m
.ends IFA_77G

** VGA (VGA_77G.sch): Variable-gm amplifier
.subckt VGA_77G VCC INP INN VCTRL GND sub OUTP OUTN
XQ1 OUTP INP net1 sub npn13G2l Nx=2 selft=0
XQ2 OUTN INN net1 sub npn13G2l Nx=2 selft=0
XQtail net1 VCTRL net2 sub npn13G2l Nx=4 selft=0
RL1 VCC OUTP 500
RL2 VCC OUTN 500
RE net2 GND 10
.ends VGA_77G

** ADC (ADC_SAR_12B.sch): 9T StrongARM comparator
.subckt ADC_SAR_12B VDD AINP AINN CLK VSS sub DOUTP DOUTN
XM1 net2 AINP net1 VSS sg13_lv_nmos w=8u l=200n ng=4 m=4 rfmode=1
XM2 net3 AINN net1 VSS sg13_lv_nmos w=8u l=200n ng=4 m=4 rfmode=1
XM9 net1 CLK VSS VSS sg13_lv_nmos w=8u l=200n ng=4 m=2 rfmode=1
XM5 DOUTP DOUTN net2 VSS sg13_lv_nmos w=4u l=200n ng=2 m=2 rfmode=1
XM6 DOUTN DOUTP net3 VSS sg13_lv_nmos w=4u l=200n ng=2 m=2 rfmode=1
XM3 DOUTP DOUTN VDD VDD sg13_lv_pmos w=4u l=200n ng=2 m=2 rfmode=1
XM4 DOUTN DOUTP VDD VDD sg13_lv_pmos w=4u l=200n ng=2 m=2 rfmode=1
XM7 DOUTP CLK VDD VDD sg13_lv_pmos w=2u l=200n ng=1 m=2 rfmode=1
XM8 DOUTN CLK VDD VDD sg13_lv_pmos w=2u l=200n ng=1 m=2 rfmode=1
.ends ADC_SAR_12B

** LNA (LNA_77G.sch): Cascode with TL matching
** TLs replaced with lumped Pi-sections (same R/L/C/len parameters)
.subckt LNA_77G V2V4 INP INN GND sub OUTP OUTN
XQ33 net8 net7 net4 sub npn13G2l Nx=4 selft=0
XQ34 net5 net1 net4 sub npn13G2l Nx=4 selft=0
XQ37 BIAS6 BIAS6 net2 sub npn13G2l Nx=1 selft=0
XQ35 net6 B3536 net8 sub npn13G2l Nx=4 selft=0
XQ36 net3 B3536 net5 sub npn13G2l Nx=4 selft=0
* TL35/36: 97um input matching
RTL35a net7 tl35m 1.07
LTL35 tl35m tl35m2 43.3p
RTL35b tl35m2 INP 1.07
CTL35a net7 GND 2.98f
CTL35b INP GND 2.98f
RTL36a net1 tl36m 1.07
LTL36 tl36m tl36m2 43.3p
RTL36b tl36m2 INN 1.07
CTL36a net1 GND 2.98f
CTL36b INN GND 2.98f
* TL37/38: 58um interstage
RTL37a net7 tl37m 0.64
LTL37 tl37m tl37m2 25.9p
RTL37b tl37m2 BIAS6 0.64
CTL37a net7 GND 1.78f
CTL37b BIAS6 GND 1.78f
RTL38a net1 tl38m 0.64
LTL38 tl38m tl38m2 25.9p
RTL38b tl38m2 BIAS6 0.64
CTL38a net1 GND 1.78f
CTL38b BIAS6 GND 1.78f
* TL39/40: 151um output
RTL39a V2V4 tl39m 1.67
LTL39 tl39m tl39m2 67.3p
RTL39b tl39m2 net6 1.67
CTL39a V2V4 GND 4.64f
CTL39b net6 GND 4.64f
RTL40a V2V4 tl40m 1.67
LTL40 tl40m tl40m2 67.3p
RTL40b tl40m2 net3 1.67
CTL40a V2V4 GND 4.64f
CTL40b net3 GND 4.64f
* PDK resistors
XR32 V2V4 BIAS6 sub rppd w=3e-6 l=18.23e-6 m=2 b=0
XR33 net2 GND sub rppd w=2.5e-6 l=10.53e-6 m=14 b=0
XR30 V2V4 B3536 sub rppd w=3e-6 l=18.23e-6 m=2 b=0
XR31 B3536 GND sub rppd w=3e-6 l=18.23e-6 m=1 b=0
XR29 net4 GND sub rsil w=7e-6 l=38.8e-6 m=4 b=0
* PDK capacitors
XC53 INP GND cap_cmim w=6e-6 l=6e-6
XC54 INN GND cap_cmim w=6e-6 l=6e-6
XC55 OUTN net6 cap_cmim w=4e-6 l=4e-6
XC56 OUTP net3 cap_cmim w=4e-6 l=4e-6
XC58 V2V4 BIAS6 cap_cmim w=100e-6 l=20e-6
XC57 V2V4 B3536 cap_cmim w=100e-6 l=15e-6
XC59 V2V4 BIAS6 cap_cmim w=100e-6 l=20e-6
XC60 V2V4 GND cap_cmim w=100e-6 l=15e-6
XC61 V2V4 GND cap_cmim w=100e-6 l=15e-6
.ends LNA_77G

** MIXER (MIXER_77G.sch): Gilbert cell with TL matching
.subckt MIXER_77G V2V4 RFP RFN LOP LON GND sub IFP IFN
XQ22 IFP BLOP ELOL sub npn13G2l Nx=4 selft=0
XQ23 IFN BLON ELOL sub npn13G2l Nx=4 selft=0
XQ24 IFP BLON ELOR sub npn13G2l Nx=4 selft=0
XQ25 IFN BLOP ELOR sub npn13G2l Nx=4 selft=0
XQ20 ELOL BRFP GND sub npn13G2l Nx=4 selft=0
XQ21 ELOR BRFN GND sub npn13G2l Nx=4 selft=0
XQ27 RFBIAS RFBIAS GND sub npn13G2l Nx=1 selft=0
XQ26 LOBIAS LOBIAS RFBIAS sub npn13G2l Nx=1 selft=0
* TL21/23: 49um LO bias stub
RTL21a BLOP tl21m 0.54
LTL21 tl21m tl21m2 21.8p
RTL21b tl21m2 LOBIAS 0.54
CTL21a BLOP GND 1.50f
CTL21b LOBIAS GND 1.50f
RTL23a BLON tl23m 0.54
LTL23 tl23m tl23m2 21.8p
RTL23b tl23m2 LOBIAS 0.54
CTL23a BLON GND 1.50f
CTL23b LOBIAS GND 1.50f
* TL22/24: 66um LO input
RTL22a BLOP tl22m 0.73
LTL22 tl22m tl22m2 29.4p
RTL22b tl22m2 LOP 0.73
CTL22a BLOP GND 2.03f
CTL22b LOP GND 2.03f
RTL24a BLON tl24m 0.73
LTL24 tl24m tl24m2 29.4p
RTL24b tl24m2 LON 0.73
CTL24a BLON GND 2.03f
CTL24b LON GND 2.03f
* TL25/27: 125um RF bias stub
RTL25a BRFP tl25m 1.39
LTL25 tl25m tl25m2 55.7p
RTL25b tl25m2 RFBIAS 1.39
CTL25a BRFP GND 3.84f
CTL25b RFBIAS GND 3.84f
RTL27a BRFN tl27m 1.39
LTL27 tl27m tl27m2 55.7p
RTL27b tl27m2 RFBIAS 1.39
CTL27a BRFN GND 3.84f
CTL27b RFBIAS GND 3.84f
* TL26/28: 125um RF input
RTL26a BRFP tl26m 1.39
LTL26 tl26m tl26m2 55.7p
RTL26b tl26m2 RFP 1.39
CTL26a BRFP GND 3.84f
CTL26b RFP GND 3.84f
RTL28a BRFN tl28m 1.39
LTL28 tl28m tl28m2 55.7p
RTL28b tl28m2 RFN 1.39
CTL28a BRFN GND 3.84f
CTL28b RFN GND 3.84f
* PDK passives
XR21 V2V4 IFP sub rppd w=3e-6 l=18.23e-6 m=2 b=0
XR22 V2V4 IFN sub rppd w=3e-6 l=18.23e-6 m=2 b=0
XR23 V2V4 LOBIAS sub rppd w=3e-6 l=27.48e-6 m=1 b=0
XC42 RFBIAS GND cap_cmim w=30e-6 l=30e-6
XC37 LOP GND cap_cmim w=5e-6 l=5e-6
XC38 LON GND cap_cmim w=5e-6 l=5e-6
XC39 RFP GND cap_cmim w=4e-6 l=4e-6
XC40 RFN GND cap_cmim w=4e-6 l=4e-6
XC41 V2V4 LOBIAS cap_cmim w=30e-6 l=30e-6
XC43 V2V4 GND cap_cmim w=30e-6 l=30e-6
.ends MIXER_77G

** ============================================================
** SUPPLIES & STIMULUS
** ============================================================
Vcc vcc 0 3.3
V2v4 v2v4 0 2.4
Vdd vdd 0 1.2
Vsub sub! 0 0
Vctrl vctrl 0 0.95

* 77GHz RF input (1mV differential)
Vrf_p rf_p 0 DC 1.0 SIN(1.0 0.5m 77G)
Vrf_n rf_n 0 DC 1.0 SIN(1.0 -0.5m 77G)

* LO at 76.99GHz -> 10MHz IF
Vlo_p lo_p 0 DC 1.0 SIN(1.0 100m 76.99G)
Vlo_n lo_n 0 DC 1.0 SIN(1.0 -100m 76.99G)

* ADC clock 100MHz (slower to reduce kickback into HBTs)
Vclk clk 0 PULSE(0 1.2 100n 200p 200p 4.8n 10n)

** ============================================================
** SIGNAL CHAIN
** ============================================================

* LNA (2.4V supply)
X_lna v2v4 rf_p rf_n 0 sub! lna_op lna_on LNA_77G

* AC coupling LNA -> Mixer RF (bias from mixer's self-bias network)
Cc_lm_p lna_op mix_rfp 500f
Cc_lm_n lna_on mix_rfn 500f
Rb_lm_p v2v4 mix_rfp 2k
Rb_lm_n v2v4 mix_rfn 2k
Rb_lm_p2 mix_rfp 0 1.5k
Rb_lm_n2 mix_rfn 0 1.5k

* Mixer (2.4V supply)
X_mixer v2v4 mix_rfp mix_rfn lo_p lo_n 0 sub! if_p if_n MIXER_77G

* AC coupling Mixer IF -> IFA input (bias at 1.3V)
Cc_mi_p if_p ifa_inp 1p
Cc_mi_n if_n ifa_inn 1p
Rb_mi_p vcc ifa_inp 10k
Rb_mi_n vcc ifa_inn 10k
Rb_mi_p2 ifa_inp 0 6.5k
Rb_mi_n2 ifa_inn 0 6.5k

* IFA (3.3V supply)
X_ifa vcc ifa_inp ifa_inn 0 sub! ifa_op ifa_on IFA_77G

* AC coupling IFA -> VGA (bias at 1.3V)
Cc_iv_p ifa_op vga_inp 1p
Cc_iv_n ifa_on vga_inn 1p
Rb_iv_p vcc vga_inp 10k
Rb_iv_n vcc vga_inn 10k
Rb_iv_p2 vga_inp 0 6.5k
Rb_iv_n2 vga_inn 0 6.5k

* VGA (3.3V supply)
X_vga vcc vga_inp vga_inn vctrl 0 sub! vga_op vga_on VGA_77G

* AC coupling VGA -> ADC (bias at VDD/2=0.6V)
Cc_va_p vga_op adc_inp 1p
Cc_va_n vga_on adc_inn 1p
Rb_va_p1 vdd adc_inp 20k
Rb_va_p2 adc_inp 0 20k
Rb_va_n1 vdd adc_inn 20k
Rb_va_n2 adc_inn 0 20k

* ADC (1.2V supply, clock delayed 100ns)
X_adc vdd adc_inp adc_inn clk 0 sub! adc_op adc_on ADC_SAR_12B

** ============================================================
** ANALYSIS
** ============================================================
.tran 0.5p 5n

.control
run
meas tran lna_swing pp v(lna_op) from=1n to=5n
meas tran if_swing pp v(if_p) from=1n to=5n
meas tran ifa_swing pp v(ifa_op) from=1n to=5n
meas tran vga_swing pp v(vga_op) from=1n to=5n
quit
.endc

.end
