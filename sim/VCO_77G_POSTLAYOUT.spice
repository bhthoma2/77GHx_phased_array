** 77 GHz VCO — POST-LAYOUT with extracted parasitics
** Adds wire R/C from PEX to pre-layout netlist
.control
pre_osdi /home/bthomas3/Videos/ngspice_pdk/install/lib/ngspice/r3_cmc.osdi
pre_osdi /home/bthomas3/Videos/ngspice_pdk/install/lib/ngspice/psp103_nqs.osdi
.endc

.lib /home/bthomas3/Videos/IHP-Open-PDK/ihp-sg13g2/libs.tech/ngspice/models/cornerHBT.lib hbt_typ
.lib /home/bthomas3/Videos/IHP-Open-PDK/ihp-sg13g2/libs.tech/ngspice/models/cornerRES.lib res_typ
.lib /home/bthomas3/Videos/IHP-Open-PDK/ihp-sg13g2/libs.tech/ngspice/models/cornerCAP.lib cap_typ

** === MIM Cap subckt ===
.subckt cap_cmim PLUS MINUS w=10e-6 l=10e-6 m=1
.param Ctot={1.5e-3*w*l*m}
C1 PLUS MINUS {Ctot}
.ends cap_cmim

** === TL Models (Z0=85 Ohm) with layout parasitics ===
** Stub TL 135µm: PEX adds R=0.189Ω, C=2.54fF per stub
.subckt TL_85_135u_PL IN OUT GND
C1 IN GND 1.385fF
R1 IN n1 1.060
L1 n1 n2 20.07pH
C2 n2 GND 3.62fF
R2 n2 n3 1.060
L2 n3 n4 20.07pH
C3 n4 GND 3.62fF
R3 n4 n5 1.060
L3 n5 OUT 20.07pH
C4 OUT GND 2.235fF
.ends

** Choke TL 105µm: PEX adds R=0.147Ω, C=1.98fF per choke
.subckt TL_85_105u_PL IN OUT GND
C1 IN GND 1.30fF
R1 IN n1 0.619
L1 n1 n2 11.71pH
C2 n2 GND 2.10fF
R2 n2 n3 0.619
L2 n3 n4 11.71pH
C3 n4 GND 2.10fF
R3 n4 n5 0.619
L3 n5 n6 11.71pH
C4 n6 GND 2.10fF
R4 n6 n7 0.619
L4 n7 OUT 11.71pH
C5 OUT GND 1.30fF
.ends

** === VCO Core with layout parasitics ===
.subckt VCO_77G_PL OUTP OUTN VTUNE VCC VSS

** Parasitic R from collector to TL (via stack: M1→TM2)
** PEX: M1-M5 total 26.8Ω, via contact R ~2Ω per stack
Rvia1 col1 OUTP 2.5
Rvia2 col2 OUTN 2.5

XQ1 col1 OUTN net_tail VSS npn13G2l Nx=2 le=2.5e-6
XQ2 col2 OUTP net_tail VSS npn13G2l Nx=2 le=2.5e-6

** Cross-coupling wire parasitics (M2, ~40µm length)
Rxc1 OUTP base2 0.15
Cxc1 base2 VSS 0.3fF
Rxc2 OUTN base1 0.15
Cxc2 base1 VSS 0.3fF

** Resonator stubs with layout parasitics
XTLRES1 OUTP res1_end VSS TL_85_135u_PL
XTLRES2 OUTN res2_end VSS TL_85_135u_PL

** Varactors + routing parasitics
Cvar1 OUTP net_var1 3fF
Rvar1 net_var1 VTUNE 500
Cvar1p OUTP VSS 0.5fF
Cvar2 OUTN net_var2 3fF
Rvar2 net_var2 VTUNE 500
Cvar2p OUTN VSS 0.5fF

** Tail with routing R
Rtail net_tail nt2 200
Rroute_tail nt2 VSS 0.3

** DC feed chokes with layout parasitics
XTLCHK1 VCC OUTP VSS TL_85_105u_PL
XTLCHK2 VCC OUTN VSS TL_85_105u_PL

** Decoupling cap + ESR
Cdecap VCC ndec 3pF
Resr ndec VSS 0.05

** VCC routing parasitics (M3 rail)
Rvcc_route VCC vcc_int 0.3
Cvcc_route vcc_int VSS 1.5fF

.ends VCO_77G_PL

** === Testbench ===
VCC VCC 0 PWL(0 0 0.1n 2.4)
VTUNE VTUNE 0 1.2

XVCO OUTP OUTN VTUNE VCC 0 VCO_77G_PL

RL1 OUTP 0 500
RL2 OUTN 0 500
Ikick OUTP 0 PWL(0 0 1p 100u 10p 100u 11p 0)

.control
tran 0.1p 5n 0 0.1p

let vdiff = v(outp) - v(outn)
meas tran vosc_pp pp vdiff from=4n to=5n
meas tran t1 when vdiff=0 rise=10
meas tran t2 when vdiff=0 rise=11
let fosc = 1/(t2-t1)

echo ""
echo "============================================="
echo "  VCO POST-LAYOUT RESULTS (with parasitics)"
echo "============================================="
echo "Oscillation frequency:"
print fosc
echo "Output swing (Vpp diff):"
print vosc_pp
echo "============================================="
echo ""
.endc
.end
