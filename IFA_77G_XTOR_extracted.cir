* Extracted by KLayout with SG13G2 LVS runset on : 05/08/2026 11:17

.SUBCKT IFA_77G_XTOR
Q$1 \$7 \$6 \$42 \$1 npn13G2l we=70n le=1000n Nx=1 m=1
Q$2 \$7 \$6 \$42 \$1 npn13G2l we=70n le=1000n Nx=1 m=1
Q$3 \$9 \$8 \$42 \$1 npn13G2l we=70n le=1000n Nx=1 m=1
Q$4 \$9 \$8 \$42 \$1 npn13G2l we=70n le=1000n Nx=1 m=1
Q$5 \$41 \$40 \$5 \$1 npn13G2l we=70n le=1000n Nx=1 m=1
Q$6 \$41 \$40 \$5 \$1 npn13G2l we=70n le=1000n Nx=1 m=1
Q$7 \$42 \$40 GND \$1 npn13G2l we=70n le=1000n Nx=1 m=1
Q$8 \$42 \$40 GND \$1 npn13G2l we=70n le=1000n Nx=1 m=1
Q$9 \$40 \$40 \$3 \$1 npn13G2l we=70n le=1000n Nx=1 m=1
Q$10 \$6 \$70 \$41 \$1 npn13G2l we=70n le=1000n Nx=1 m=1
Q$11 \$6 \$70 \$41 \$1 npn13G2l we=70n le=1000n Nx=1 m=1
Q$12 \$8 \$71 \$41 \$1 npn13G2l we=70n le=1000n Nx=1 m=1
Q$13 \$8 \$71 \$41 \$1 npn13G2l we=70n le=1000n Nx=1 m=1
R$14 VCC \$40 \$1 rppd w=3u l=18.23u ps=0u b=0 m=1
R$15 \$3 GND \$1 rppd w=3u l=5u ps=0u b=0 m=1
R$16 \$5 GND \$1 rppd w=3u l=5u ps=0u b=0 m=1
R$17 VCC \$6 \$1 rppd w=3u l=8.33u ps=0u b=0 m=1
R$18 VCC \$8 \$1 rppd w=3u l=8.33u ps=0u b=0 m=1
R$19 VCC \$7 \$1 rppd w=3u l=8.33u ps=0u b=0 m=1
R$20 VCC \$9 \$1 rppd w=3u l=8.33u ps=0u b=0 m=1
C$21 VCC$1 GND cap_cmim w=6.99u l=6.99u A=48.8601p P=27.96u m=1
C$22 VCC$2 GND cap_cmim w=6.99u l=6.99u A=48.8601p P=27.96u m=1
.ENDS IFA_77G_XTOR
