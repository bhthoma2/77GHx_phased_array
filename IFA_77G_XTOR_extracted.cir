* Extracted by KLayout with SG13G2 LVS runset on : 28/07/2026 15:39

.SUBCKT IFA_77G_XTOR
Q$1 \$4 \$4 \$17 \$1 npn13G2l we=70n le=1000n Nx=1 m=1
Q$2 \$4 \$4 \$17 \$1 npn13G2l we=70n le=1000n Nx=1 m=1
Q$3 \$4 \$4 \$17 \$1 npn13G2l we=70n le=1000n Nx=1 m=1
Q$4 \$4 \$4 \$17 \$1 npn13G2l we=70n le=1000n Nx=1 m=1
Q$5 \$17 \$2 \$2 \$1 npn13G2l we=70n le=1000n Nx=1 m=1
Q$6 \$17 \$2 \$2 \$1 npn13G2l we=70n le=1000n Nx=1 m=1
Q$7 \$17 \$2 \$2 \$1 npn13G2l we=70n le=1000n Nx=1 m=1
Q$8 \$17 \$2 \$2 \$1 npn13G2l we=70n le=1000n Nx=1 m=1
Q$9 \$2 \$2 \$2 \$1 npn13G2l we=70n le=1000n Nx=1 m=1
Q$10 \$4 \$69 \$17 \$1 npn13G2l we=70n le=1000n Nx=1 m=1
Q$11 \$4 \$69 \$17 \$1 npn13G2l we=70n le=1000n Nx=1 m=1
Q$12 \$4 \$70 \$17 \$1 npn13G2l we=70n le=1000n Nx=1 m=1
Q$13 \$4 \$70 \$17 \$1 npn13G2l we=70n le=1000n Nx=1 m=1
R$14 \$2 \$3 \$1 rppd w=3u l=18.23u ps=0u b=0 m=1
R$15 \$2 \$2 \$1 rppd w=3u l=5u ps=0u b=0 m=1
R$16 \$2 \$2 \$1 rppd w=3u l=5u ps=0u b=0 m=1
R$17 \$4 \$3 \$1 rppd w=3u l=8.33u ps=0u b=0 m=1
R$18 \$4 \$3 \$1 rppd w=3u l=8.33u ps=0u b=0 m=1
R$19 \$4 \$3 \$1 rppd w=3u l=8.33u ps=0u b=0 m=1
R$20 \$4 \$3 \$1 rppd w=3u l=8.33u ps=0u b=0 m=1
C$21 \$48 \$46 cap_cmim w=6.99u l=6.99u A=48.8601p P=27.96u m=1
C$22 \$56 \$47 cap_cmim w=6.99u l=6.99u A=48.8601p P=27.96u m=1
.ENDS IFA_77G_XTOR
