* Extracted by KLayout with SG13G2 LVS runset on : 28/07/2026 15:35

.SUBCKT IFA_77G_XTOR
Q$1 \$9 \$10 \$2 \$1 npn13G2l we=70n le=1000n Nx=1 m=1
Q$2 \$9 \$10 \$2 \$1 npn13G2l we=70n le=1000n Nx=1 m=1
Q$3 \$11 \$12 \$2 \$1 npn13G2l we=70n le=1000n Nx=1 m=1
Q$4 \$11 \$12 \$2 \$1 npn13G2l we=70n le=1000n Nx=1 m=1
Q$5 \$43 \$44 \$2 \$1 npn13G2l we=70n le=1000n Nx=1 m=1
Q$6 \$43 \$44 \$2 \$1 npn13G2l we=70n le=1000n Nx=1 m=1
Q$7 \$45 \$46 \$2 \$1 npn13G2l we=70n le=1000n Nx=1 m=1
Q$8 \$45 \$46 \$2 \$1 npn13G2l we=70n le=1000n Nx=1 m=1
Q$9 \$2 \$2 \$2 \$1 npn13G2l we=70n le=1000n Nx=1 m=1
Q$10 \$76 \$77 \$2 \$1 npn13G2l we=70n le=1000n Nx=1 m=1
Q$11 \$76 \$77 \$2 \$1 npn13G2l we=70n le=1000n Nx=1 m=1
Q$12 \$78 \$79 \$2 \$1 npn13G2l we=70n le=1000n Nx=1 m=1
Q$13 \$78 \$79 \$2 \$1 npn13G2l we=70n le=1000n Nx=1 m=1
R$14 \$3 \$8 \$1 rppd w=3u l=18.23u ps=0u b=0 m=1
R$15 \$4 \$6 \$1 rppd w=3u l=5u ps=0u b=0 m=1
R$16 \$5 \$7 \$1 rppd w=3u l=5u ps=0u b=0 m=1
R$17 \$86 \$87 \$1 rppd w=3u l=8.33u ps=0u b=0 m=1
R$18 \$89 \$88 \$1 rppd w=3u l=8.33u ps=0u b=0 m=1
R$19 \$91 \$90 \$1 rppd w=3u l=8.33u ps=0u b=0 m=1
R$20 \$92 \$93 \$1 rppd w=3u l=8.33u ps=0u b=0 m=1
C$21 \$59 \$57 cap_cmim w=6.99u l=6.99u A=48.8601p P=27.96u m=1
C$22 \$60 \$58 cap_cmim w=6.99u l=6.99u A=48.8601p P=27.96u m=1
.ENDS IFA_77G_XTOR
