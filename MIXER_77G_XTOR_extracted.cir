* Extracted by KLayout with SG13G2 LVS runset on : 05/08/2026 22:53

.SUBCKT MIXER_77G_XTOR
Q$1 \$2 \$2 \$6 \$1 npn13G2l we=70n le=1000n Nx=1 m=1
Q$2 \$21 RFP_I \$6 \$1 npn13G2l we=70n le=1000n Nx=1 m=1
Q$3 \$22 RFN_I \$6 \$1 npn13G2l we=70n le=1000n Nx=1 m=1
Q$4 \$21 RFP_I \$6 \$1 npn13G2l we=70n le=1000n Nx=1 m=1
Q$5 \$22 RFN_I \$6 \$1 npn13G2l we=70n le=1000n Nx=1 m=1
Q$6 \$21 RFP_I \$6 \$1 npn13G2l we=70n le=1000n Nx=1 m=1
Q$7 \$22 RFN_I \$6 \$1 npn13G2l we=70n le=1000n Nx=1 m=1
Q$8 \$21 RFP_I \$6 \$1 npn13G2l we=70n le=1000n Nx=1 m=1
Q$9 \$22 RFN_I \$6 \$1 npn13G2l we=70n le=1000n Nx=1 m=1
Q$10 \$69 \$60 \$21 \$1 npn13G2l we=70n le=1000n Nx=1 m=1
Q$11 2V4 \$57 \$21 \$1 npn13G2l we=70n le=1000n Nx=1 m=1
Q$12 \$71 \$60 \$22 \$1 npn13G2l we=70n le=1000n Nx=1 m=1
Q$13 \$69 \$57 \$22 \$1 npn13G2l we=70n le=1000n Nx=1 m=1
Q$14 \$69 \$60 \$21 \$1 npn13G2l we=70n le=1000n Nx=1 m=1
Q$15 2V4 \$57 \$21 \$1 npn13G2l we=70n le=1000n Nx=1 m=1
Q$16 \$71 \$60 \$22 \$1 npn13G2l we=70n le=1000n Nx=1 m=1
Q$17 \$69 \$57 \$22 \$1 npn13G2l we=70n le=1000n Nx=1 m=1
Q$18 \$69 \$60 \$21 \$1 npn13G2l we=70n le=1000n Nx=1 m=1
Q$19 2V4 \$57 \$21 \$1 npn13G2l we=70n le=1000n Nx=1 m=1
Q$20 \$71 \$60 \$22 \$1 npn13G2l we=70n le=1000n Nx=1 m=1
Q$21 \$69 \$57 \$22 \$1 npn13G2l we=70n le=1000n Nx=1 m=1
Q$22 \$69 \$60 \$21 \$1 npn13G2l we=70n le=1000n Nx=1 m=1
Q$23 2V4 \$57 \$21 \$1 npn13G2l we=70n le=1000n Nx=1 m=1
Q$24 \$71 \$60 \$22 \$1 npn13G2l we=70n le=1000n Nx=1 m=1
Q$25 \$69 \$57 \$22 \$1 npn13G2l we=70n le=1000n Nx=1 m=1
Q$26 \$146 \$146 \$2 \$1 npn13G2l we=70n le=1000n Nx=1 m=1
R$27 2V4 2V4 \$1 rppd w=3u l=18.23u ps=0u b=0 m=1
R$28 2V4 2V4 \$1 rppd w=3u l=18.23u ps=0u b=0 m=1
R$29 2V4 2V4 \$1 rppd w=3u l=18.23u ps=0u b=0 m=1
R$30 2V4 2V4 \$1 rppd w=3u l=18.23u ps=0u b=0 m=1
R$31 2V4 \$165 \$1 rppd w=3u l=27.48u ps=0u b=0 m=1
R$32 2V4 2V4 \$1 rppd w=3u l=27.48u ps=0u b=0 m=1
C$33 2V4$2 \$6 cap_cmim w=6.99u l=6.99u A=48.8601p P=27.96u m=1
C$34 2V4$3 \$6 cap_cmim w=6.99u l=6.99u A=48.8601p P=27.96u m=1
C$35 RFN RFN_I cap_cmim w=6.99u l=6.99u A=48.8601p P=27.96u m=1
C$36 RFP RFP_I cap_cmim w=6.99u l=6.99u A=48.8601p P=27.96u m=1
C$37 LON \$60 cap_cmim w=6.99u l=6.99u A=48.8601p P=27.96u m=1
C$38 LOP \$57 cap_cmim w=6.99u l=6.99u A=48.8601p P=27.96u m=1
C$39 2V4$1 \$6 cap_cmim w=6.99u l=6.99u A=48.8601p P=27.96u m=1
.ENDS MIXER_77G_XTOR
