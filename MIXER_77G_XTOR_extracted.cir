* Extracted by KLayout with SG13G2 LVS runset on : 28/07/2026 23:22

.SUBCKT MIXER_77G_XTOR
Q$1 \$2 \$2 \$6 \$1 npn13G2l we=70n le=1000n Nx=1 m=1
Q$2 \$22 \$21 \$6 \$1 npn13G2l we=70n le=1000n Nx=1 m=1
Q$3 \$23 \$24 \$6 \$1 npn13G2l we=70n le=1000n Nx=1 m=1
Q$4 \$22 \$21 \$6 \$1 npn13G2l we=70n le=1000n Nx=1 m=1
Q$5 \$23 \$24 \$6 \$1 npn13G2l we=70n le=1000n Nx=1 m=1
Q$6 \$22 \$21 \$6 \$1 npn13G2l we=70n le=1000n Nx=1 m=1
Q$7 \$23 \$24 \$6 \$1 npn13G2l we=70n le=1000n Nx=1 m=1
Q$8 \$22 \$21 \$6 \$1 npn13G2l we=70n le=1000n Nx=1 m=1
Q$9 \$23 \$24 \$6 \$1 npn13G2l we=70n le=1000n Nx=1 m=1
Q$10 \$71 \$62 \$22 \$1 npn13G2l we=70n le=1000n Nx=1 m=1
Q$11 \$72 \$59 \$22 \$1 npn13G2l we=70n le=1000n Nx=1 m=1
Q$12 \$73 \$62 \$23 \$1 npn13G2l we=70n le=1000n Nx=1 m=1
Q$13 \$71 \$59 \$23 \$1 npn13G2l we=70n le=1000n Nx=1 m=1
Q$14 \$71 \$62 \$22 \$1 npn13G2l we=70n le=1000n Nx=1 m=1
Q$15 \$72 \$59 \$22 \$1 npn13G2l we=70n le=1000n Nx=1 m=1
Q$16 \$73 \$62 \$23 \$1 npn13G2l we=70n le=1000n Nx=1 m=1
Q$17 \$71 \$59 \$23 \$1 npn13G2l we=70n le=1000n Nx=1 m=1
Q$18 \$71 \$62 \$22 \$1 npn13G2l we=70n le=1000n Nx=1 m=1
Q$19 \$72 \$59 \$22 \$1 npn13G2l we=70n le=1000n Nx=1 m=1
Q$20 \$73 \$62 \$23 \$1 npn13G2l we=70n le=1000n Nx=1 m=1
Q$21 \$71 \$59 \$23 \$1 npn13G2l we=70n le=1000n Nx=1 m=1
Q$22 \$71 \$62 \$22 \$1 npn13G2l we=70n le=1000n Nx=1 m=1
Q$23 \$72 \$59 \$22 \$1 npn13G2l we=70n le=1000n Nx=1 m=1
Q$24 \$73 \$62 \$23 \$1 npn13G2l we=70n le=1000n Nx=1 m=1
Q$25 \$71 \$59 \$23 \$1 npn13G2l we=70n le=1000n Nx=1 m=1
Q$26 \$156 \$156 \$2 \$1 npn13G2l we=70n le=1000n Nx=1 m=1
R$27 \$72 \$72 \$1 rppd w=3u l=18.23u ps=0u b=0 m=1
R$28 \$161 \$160 \$1 rppd w=3u l=18.23u ps=0u b=0 m=1
R$29 \$72 \$72 \$1 rppd w=3u l=18.23u ps=0u b=0 m=1
R$30 \$162 \$163 \$1 rppd w=3u l=18.23u ps=0u b=0 m=1
R$31 \$72 \$170 \$1 rppd w=3u l=27.48u ps=0u b=0 m=1
R$32 \$72 \$72 \$1 rppd w=3u l=27.48u ps=0u b=0 m=1
C$33 \$167 \$166 cap_cmim w=6.99u l=6.99u A=48.8601p P=27.96u m=1
C$34 \$169 \$168 cap_cmim w=6.99u l=6.99u A=48.8601p P=27.96u m=1
C$35 \$10 \$9 cap_cmim w=6.99u l=6.99u A=48.8601p P=27.96u m=1
C$36 \$8 \$7 cap_cmim w=6.99u l=6.99u A=48.8601p P=27.96u m=1
C$37 \$85 \$84 cap_cmim w=6.99u l=6.99u A=48.8601p P=27.96u m=1
C$38 \$83 \$82 cap_cmim w=6.99u l=6.99u A=48.8601p P=27.96u m=1
C$39 \$165 \$164 cap_cmim w=6.99u l=6.99u A=48.8601p P=27.96u m=1
.ENDS MIXER_77G_XTOR
