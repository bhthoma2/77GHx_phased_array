* Extracted by KLayout with SG13G2 LVS runset on : 24/07/2026 10:19

.SUBCKT PHASED_ARRAY_77G_XTOR G1 G1|G2 W W$1
Q$1 \$510 \$509 \$527 \$1 npn13G2l we=70n le=1000n Nx=1 m=8
Q$2 \$511 \$512 \$528 \$1 npn13G2l we=70n le=1000n Nx=1 m=8
Q$17 \$747 \$738 \$510 \$1 npn13G2l we=70n le=1000n Nx=1 m=8
Q$18 \$748 \$738 \$511 \$1 npn13G2l we=70n le=1000n Nx=1 m=8
Q$19 \$793 \$775 \$805 \$1 npn13G2l we=70n le=1000n Nx=1 m=4
Q$20 \$794 \$776 \$806 \$1 npn13G2l we=70n le=1000n Nx=1 m=4
Q$21 \$795 \$777 \$807 \$1 npn13G2l we=70n le=1000n Nx=1 m=4
Q$22 \$796 \$778 \$808 \$1 npn13G2l we=70n le=1000n Nx=1 m=4
Q$23 \$797 \$779 \$809 \$1 npn13G2l we=70n le=1000n Nx=1 m=4
Q$24 \$798 \$780 \$810 \$1 npn13G2l we=70n le=1000n Nx=1 m=4
Q$53 \$992 \$991 \$793 \$1 npn13G2l we=70n le=1000n Nx=1 m=4
Q$54 \$993 \$991 \$794 \$1 npn13G2l we=70n le=1000n Nx=1 m=4
Q$55 \$994 \$995 \$795 \$1 npn13G2l we=70n le=1000n Nx=1 m=4
Q$56 \$996 \$995 \$796 \$1 npn13G2l we=70n le=1000n Nx=1 m=4
Q$57 \$998 \$997 \$797 \$1 npn13G2l we=70n le=1000n Nx=1 m=4
Q$58 \$999 \$997 \$798 \$1 npn13G2l we=70n le=1000n Nx=1 m=4
Q$81 \$1415 \$1416 \$1417 \$1 npn13G2l we=70n le=1000n Nx=1 m=2
Q$83 \$1418 \$1419 \$1417 \$1 npn13G2l we=70n le=1000n Nx=1 m=2
Q$85 \$1438 \$1438 \$1459 \$1 npn13G2l we=70n le=1000n Nx=1 m=8
Q$87 \$1439 \$1439 \$1460 \$1 npn13G2l we=70n le=1000n Nx=1 m=8
Q$89 \$1440 \$1440 \$1461 \$1 npn13G2l we=70n le=1000n Nx=1 m=8
Q$97 \$1516 \$1516 \$1415 \$1 npn13G2l we=70n le=1000n Nx=1 m=2
Q$98 \$1516 \$1516 \$1418 \$1 npn13G2l we=70n le=1000n Nx=1 m=2
Q$113 \$1712 \$1685 \$1438 \$1 npn13G2l we=70n le=1000n Nx=1 m=8
Q$117 \$1713 \$1686 \$1439 \$1 npn13G2l we=70n le=1000n Nx=1 m=8
Q$121 \$1714 \$1687 \$1440 \$1 npn13G2l we=70n le=1000n Nx=1 m=8
Q$137 \$2098 \$2099 \$2117 \$1 npn13G2l we=70n le=1000n Nx=1 m=8
Q$140 \$2100 \$2101 \$2118 \$1 npn13G2l we=70n le=1000n Nx=1 m=8
Q$153 \$2308 \$2307 \$2357 \$1 npn13G2l we=70n le=1000n Nx=1 m=4
Q$154 \$2309 \$2310 \$2358 \$1 npn13G2l we=70n le=1000n Nx=1 m=4
Q$155 \$2312 \$2311 \$2359 \$1 npn13G2l we=70n le=1000n Nx=1 m=4
Q$156 \$2313 \$2314 \$2360 \$1 npn13G2l we=70n le=1000n Nx=1 m=4
Q$157 \$2316 \$2315 \$2361 \$1 npn13G2l we=70n le=1000n Nx=1 m=4
Q$158 \$2317 \$2318 \$2362 \$1 npn13G2l we=70n le=1000n Nx=1 m=4
Q$159 \$2369 \$2370 \$2098 \$1 npn13G2l we=70n le=1000n Nx=1 m=8
Q$160 \$2371 \$2370 \$2100 \$1 npn13G2l we=70n le=1000n Nx=1 m=8
Q$187 \$2580 \$2550 \$2308 \$1 npn13G2l we=70n le=1000n Nx=1 m=4
Q$188 \$2581 \$2550 \$2309 \$1 npn13G2l we=70n le=1000n Nx=1 m=4
Q$189 \$2582 \$2551 \$2312 \$1 npn13G2l we=70n le=1000n Nx=1 m=4
Q$190 \$2583 \$2551 \$2313 \$1 npn13G2l we=70n le=1000n Nx=1 m=4
Q$191 \$2584 \$2552 \$2316 \$1 npn13G2l we=70n le=1000n Nx=1 m=4
Q$192 \$2585 \$2552 \$2317 \$1 npn13G2l we=70n le=1000n Nx=1 m=4
Q$217 \$3012 \$3012 \$3033 \$1 npn13G2l we=70n le=1000n Nx=1 m=8
Q$219 \$3013 \$3013 \$3034 \$1 npn13G2l we=70n le=1000n Nx=1 m=8
Q$221 \$3014 \$3014 \$3035 \$1 npn13G2l we=70n le=1000n Nx=1 m=8
Q$241 \$3261 \$3234 \$3012 \$1 npn13G2l we=70n le=1000n Nx=1 m=8
Q$245 \$3262 \$3235 \$3013 \$1 npn13G2l we=70n le=1000n Nx=1 m=8
Q$249 \$3263 \$3236 \$3014 \$1 npn13G2l we=70n le=1000n Nx=1 m=8
Q$265 G1|G2 G1|G2 \$3367 \$1 npn13G2l we=70n le=1000n Nx=1 m=4
Q$269 \$3664 \$3663 \$3679 \$1 npn13G2l we=70n le=1000n Nx=1 m=8
Q$271 \$3665 \$3666 \$3680 \$1 npn13G2l we=70n le=1000n Nx=1 m=8
Q$285 \$3900 \$3829 \$3664 \$1 npn13G2l we=70n le=1000n Nx=1 m=8
Q$286 \$3901 \$3829 \$3665 \$1 npn13G2l we=70n le=1000n Nx=1 m=8
Q$301 \$4391 \$4392 \$4393 \$1 npn13G2l we=70n le=1000n Nx=1 m=1
Q$302 \$4394 \$4395 \$4396 \$1 npn13G2l we=70n le=1000n Nx=1 m=1
Q$303 \$4391 \$4488 \$4393 \$1 npn13G2l we=70n le=1000n Nx=1 m=1
Q$304 \$4394 \$4489 \$4396 \$1 npn13G2l we=70n le=1000n Nx=1 m=1
Q$305 \$4572 \$4573 \$4591 \$1 npn13G2l we=70n le=1000n Nx=1 m=2
Q$306 \$4574 \$4575 \$4591 \$1 npn13G2l we=70n le=1000n Nx=1 m=2
Q$307 \$4576 \$4577 \$4592 \$1 npn13G2l we=70n le=1000n Nx=1 m=4
Q$308 \$4578 \$4577 \$4592 \$1 npn13G2l we=70n le=1000n Nx=1 m=4
Q$317 \$4879 \$4880 \$4881 \$1 npn13G2l we=70n le=1000n Nx=1 m=2
Q$318 \$4891 \$4882 \$4881 \$1 npn13G2l we=70n le=1000n Nx=1 m=2
Q$321 \$5483 \$5484 \$5485 \$1 npn13G2l we=70n le=1000n Nx=1 m=8
Q$322 \$5487 \$5488 \$5486 \$1 npn13G2l we=70n le=1000n Nx=1 m=8
Q$331 \$5692 \$5691 \$5709 \$1 npn13G2l we=70n le=1000n Nx=1 m=2
Q$332 \$5693 \$5694 \$5709 \$1 npn13G2l we=70n le=1000n Nx=1 m=2
Q$341 \$5904 \$5905 \$5483 \$1 npn13G2l we=70n le=1000n Nx=1 m=8
Q$342 \$5906 \$5905 \$5487 \$1 npn13G2l we=70n le=1000n Nx=1 m=8
Q$343 \$5923 \$5924 \$5692 \$1 npn13G2l we=70n le=1000n Nx=1 m=2
Q$345 \$5923 \$5924 \$5693 \$1 npn13G2l we=70n le=1000n Nx=1 m=2
Q$361 \$6564 \$6565 \$6566 \$1 npn13G2l we=70n le=1000n Nx=1 m=2
Q$362 \$6567 \$6568 \$6566 \$1 npn13G2l we=70n le=1000n Nx=1 m=2
Q$365 \$6743 \$6744 \$6745 \$1 npn13G2l we=70n le=1000n Nx=1 m=2
Q$366 \$6746 \$6747 \$6745 \$1 npn13G2l we=70n le=1000n Nx=1 m=2
Q$369 \$7314 \$7315 \$7339 \$1 npn13G2l we=70n le=1000n Nx=1 m=1
Q$370 \$7314 \$7316 \$7339 \$1 npn13G2l we=70n le=1000n Nx=1 m=1
Q$371 \$7314 \$7317 \$7339 \$1 npn13G2l we=70n le=1000n Nx=1 m=1
Q$372 \$7314 \$7318 \$7339 \$1 npn13G2l we=70n le=1000n Nx=1 m=1
Q$373 \$7314 \$7319 \$7339 \$1 npn13G2l we=70n le=1000n Nx=1 m=1
Q$374 \$7314 \$7320 \$7339 \$1 npn13G2l we=70n le=1000n Nx=1 m=1
Q$375 \$7314 \$7321 \$7339 \$1 npn13G2l we=70n le=1000n Nx=1 m=1
Q$376 \$7314 \$7322 \$7339 \$1 npn13G2l we=70n le=1000n Nx=1 m=1
Q$377 \$7314 \$7323 \$7339 \$1 npn13G2l we=70n le=1000n Nx=1 m=1
Q$378 \$7314 \$7324 \$7339 \$1 npn13G2l we=70n le=1000n Nx=1 m=1
Q$379 \$7314 \$7325 \$7339 \$1 npn13G2l we=70n le=1000n Nx=1 m=1
Q$380 \$7314 \$7326 \$7339 \$1 npn13G2l we=70n le=1000n Nx=1 m=1
Q$381 \$7314 \$7364 \$7339 \$1 npn13G2l we=70n le=1000n Nx=1 m=1
Q$382 \$7314 \$7365 \$7339 \$1 npn13G2l we=70n le=1000n Nx=1 m=1
Q$383 \$7314 \$7366 \$7339 \$1 npn13G2l we=70n le=1000n Nx=1 m=1
Q$384 \$7314 \$7367 \$7339 \$1 npn13G2l we=70n le=1000n Nx=1 m=1
Q$385 \$7314 \$7368 \$7339 \$1 npn13G2l we=70n le=1000n Nx=1 m=1
Q$386 \$7314 \$7369 \$7339 \$1 npn13G2l we=70n le=1000n Nx=1 m=1
Q$387 \$7314 \$7370 \$7339 \$1 npn13G2l we=70n le=1000n Nx=1 m=1
Q$388 \$7314 \$7371 \$7339 \$1 npn13G2l we=70n le=1000n Nx=1 m=1
Q$389 \$7314 \$7372 \$7339 \$1 npn13G2l we=70n le=1000n Nx=1 m=1
Q$390 \$7314 \$7373 \$7339 \$1 npn13G2l we=70n le=1000n Nx=1 m=1
Q$391 \$7314 \$7374 \$7339 \$1 npn13G2l we=70n le=1000n Nx=1 m=1
Q$392 \$7314 \$7375 \$7339 \$1 npn13G2l we=70n le=1000n Nx=1 m=1
Q$393 \$7562 \$7563 \$7616 \$1 npn13G2l we=70n le=1000n Nx=1 m=2
Q$394 \$7564 \$7565 \$7616 \$1 npn13G2l we=70n le=1000n Nx=1 m=2
Q$395 \$7566 \$7567 \$7616 \$1 npn13G2l we=70n le=1000n Nx=1 m=2
Q$396 \$7568 \$7569 \$7616 \$1 npn13G2l we=70n le=1000n Nx=1 m=2
Q$397 \$7570 \$7571 \$7616 \$1 npn13G2l we=70n le=1000n Nx=1 m=2
Q$398 \$7572 \$7573 \$7616 \$1 npn13G2l we=70n le=1000n Nx=1 m=2
Q$399 \$7574 \$7575 \$7616 \$1 npn13G2l we=70n le=1000n Nx=1 m=2
Q$400 \$7576 \$7577 \$7616 \$1 npn13G2l we=70n le=1000n Nx=1 m=2
Q$401 \$7578 \$7579 \$7616 \$1 npn13G2l we=70n le=1000n Nx=1 m=2
Q$402 \$7580 \$7581 \$7616 \$1 npn13G2l we=70n le=1000n Nx=1 m=2
Q$403 \$7582 \$7583 \$7616 \$1 npn13G2l we=70n le=1000n Nx=1 m=2
Q$404 \$7584 \$7585 \$7616 \$1 npn13G2l we=70n le=1000n Nx=1 m=2
Q$405 \$7586 \$7587 \$7616 \$1 npn13G2l we=70n le=1000n Nx=1 m=2
Q$406 \$7588 \$7589 \$7616 \$1 npn13G2l we=70n le=1000n Nx=1 m=2
Q$407 \$7590 \$7591 \$7616 \$1 npn13G2l we=70n le=1000n Nx=1 m=2
Q$408 \$7592 \$7593 \$7616 \$1 npn13G2l we=70n le=1000n Nx=1 m=2
Q$409 \$7594 \$7595 \$7616 \$1 npn13G2l we=70n le=1000n Nx=1 m=2
Q$410 \$7596 \$7597 \$7616 \$1 npn13G2l we=70n le=1000n Nx=1 m=2
R$429 \$1181 \$1192 \$1 rppd w=0.5u l=0.5u ps=0u b=0 m=1
R$430 \$1206 \$1207 \$1 rppd w=0.5u l=0.5u ps=0u b=0 m=1
R$431 \$1210 \$1209 \$1 rppd w=0.5u l=0.5u ps=0u b=0 m=1
R$432 \$1213 \$1212 \$1 rppd w=0.5u l=0.5u ps=0u b=0 m=1
R$433 \$1336 \$1337 \$1 rppd w=0.5u l=0.5u ps=0u b=0 m=1
R$434 \$1382 \$1381 \$1 rppd w=0.5u l=0.5u ps=0u b=0 m=1
R$435 \$1383 \$1384 \$1 rppd w=0.5u l=0.5u ps=0u b=0 m=1
R$436 \$1385 \$1386 \$1 rppd w=0.5u l=0.5u ps=0u b=0 m=1
R$437 \$1809 \$1810 \$1 rppd w=0.5u l=0.5u ps=0u b=0 m=1
R$438 \$1812 \$1811 \$1 rppd w=0.5u l=0.5u ps=0u b=0 m=1
R$439 \$1815 \$1814 \$1 rppd w=0.5u l=0.5u ps=0u b=0 m=1
R$440 \$1818 \$1817 \$1 rppd w=0.5u l=0.5u ps=0u b=0 m=1
R$441 \$1820 \$1819 \$1 rppd w=0.5u l=0.5u ps=0u b=0 m=1
R$442 \$1822 \$1821 \$1 rppd w=0.5u l=0.5u ps=0u b=0 m=1
R$443 \$2779 \$2778 \$1 rppd w=0.5u l=0.5u ps=0u b=0 m=1
R$444 \$2780 \$2781 \$1 rppd w=0.5u l=0.5u ps=0u b=0 m=1
R$445 \$2782 \$2783 \$1 rppd w=0.5u l=0.5u ps=0u b=0 m=1
R$446 \$2785 \$2784 \$1 rppd w=0.5u l=0.5u ps=0u b=0 m=1
R$447 \$2967 \$2968 \$1 rppd w=0.5u l=0.5u ps=0u b=0 m=1
R$448 \$2969 \$2970 \$1 rppd w=0.5u l=0.5u ps=0u b=0 m=1
R$449 \$2971 \$2972 \$1 rppd w=0.5u l=0.5u ps=0u b=0 m=1
R$450 \$3167 \$3367 \$1 rppd w=0.5u l=0.5u ps=0u b=0 m=1
R$451 \$3452 \$3451 \$1 rppd w=0.5u l=0.5u ps=0u b=0 m=1
R$452 \$3454 \$3453 \$1 rppd w=0.5u l=0.5u ps=0u b=0 m=1
R$453 \$3455 \$3456 \$1 rppd w=0.5u l=0.5u ps=0u b=0 m=1
R$454 \$3457 \$3458 \$1 rppd w=0.5u l=0.5u ps=0u b=0 m=1
R$455 \$3459 \$3460 \$1 rppd w=0.5u l=0.5u ps=0u b=0 m=1
R$456 \$3462 \$3461 \$1 rppd w=0.5u l=0.5u ps=0u b=0 m=1
R$457 \$4300 \$4299 \$1 rppd w=0.5u l=0.5u ps=0u b=0 m=1
R$458 \$4302 \$4301 \$1 rppd w=0.5u l=0.5u ps=0u b=0 m=1
R$459 \$4303 \$4304 \$1 rppd w=0.5u l=0.5u ps=0u b=0 m=1
R$460 \$4305 \$4306 \$1 rppd w=0.5u l=0.5u ps=0u b=0 m=1
R$461 \$4307 \$4308 \$1 rppd w=0.5u l=0.5u ps=0u b=0 m=1
R$462 \$4310 \$4309 \$1 rppd w=0.5u l=0.5u ps=0u b=0 m=1
R$463 \$4205 \$4206 \$1 rppd w=0.5u l=0.5u ps=0u b=0 m=1
R$464 \$4687 \$4688 \$1 rppd w=0.5u l=0.5u ps=0u b=0 m=1
R$465 \$4909 \$4908 \$1 rppd w=0.5u l=0.5u ps=0u b=0 m=1
R$466 \$4487 \$4486 \$1 rppd w=0.5u l=0.5u ps=0u b=0 m=1
R$467 \$4690 \$4689 \$1 rppd w=0.5u l=0.5u ps=0u b=0 m=1
R$468 \$4911 \$4910 \$1 rppd w=0.5u l=0.5u ps=0u b=0 m=1
R$469 \$4996 \$4997 \$1 rppd w=0.5u l=0.5u ps=0u b=0 m=1
R$470 \$6058 \$6057 \$1 rppd w=0.5u l=0.5u ps=0u b=0 m=1
R$471 \$6060 \$6059 \$1 rppd w=0.5u l=0.5u ps=0u b=0 m=1
R$472 \$6259 \$6258 \$1 rppd w=0.5u l=0.5u ps=0u b=0 m=1
R$473 \$7035 \$7034 \$1 rppd w=0.5u l=0.5u ps=0u b=0 m=1
R$474 \$7036 \$7037 \$1 rppd w=0.5u l=0.5u ps=0u b=0 m=1
R$475 \$7038 \$7039 \$1 rppd w=0.5u l=0.5u ps=0u b=0 m=1
R$476 \$7040 \$7041 \$1 rppd w=0.5u l=0.5u ps=0u b=0 m=1
R$477 \$7042 \$7043 \$1 rppd w=0.5u l=0.5u ps=0u b=0 m=1
R$478 \$7045 \$7044 \$1 rppd w=0.5u l=0.5u ps=0u b=0 m=1
R$479 \$7046 \$7047 \$1 rppd w=0.5u l=0.5u ps=0u b=0 m=1
R$480 \$7048 \$7049 \$1 rppd w=0.5u l=0.5u ps=0u b=0 m=1
R$481 \$7050 \$7051 \$1 rppd w=0.5u l=0.5u ps=0u b=0 m=1
R$482 \$7052 \$7053 \$1 rppd w=0.5u l=0.5u ps=0u b=0 m=1
R$483 \$7054 \$7055 \$1 rppd w=0.5u l=0.5u ps=0u b=0 m=1
R$484 \$7057 \$7056 \$1 rppd w=0.5u l=0.5u ps=0u b=0 m=1
R$485 \$7074 \$7176 \$1 rppd w=0.5u l=0.5u ps=0u b=0 m=1
R$486 \$7075 \$7177 \$1 rppd w=0.5u l=0.5u ps=0u b=0 m=1
R$487 \$7076 \$7178 \$1 rppd w=0.5u l=0.5u ps=0u b=0 m=1
R$488 \$7077 \$7179 \$1 rppd w=0.5u l=0.5u ps=0u b=0 m=1
R$489 \$7078 \$7180 \$1 rppd w=0.5u l=0.5u ps=0u b=0 m=1
R$490 \$7079 \$7181 \$1 rppd w=0.5u l=0.5u ps=0u b=0 m=1
R$491 \$7080 \$7182 \$1 rppd w=0.5u l=0.5u ps=0u b=0 m=1
R$492 \$7081 \$7183 \$1 rppd w=0.5u l=0.5u ps=0u b=0 m=1
R$493 \$7082 \$7184 \$1 rppd w=0.5u l=0.5u ps=0u b=0 m=1
R$494 \$7083 \$7185 \$1 rppd w=0.5u l=0.5u ps=0u b=0 m=1
R$495 \$7084 \$7186 \$1 rppd w=0.5u l=0.5u ps=0u b=0 m=1
R$496 \$7085 \$7187 \$1 rppd w=0.5u l=0.5u ps=0u b=0 m=1
R$497 \$7725 \$7797 \$1 rppd w=0.5u l=0.5u ps=0u b=0 m=1
R$498 \$7726 \$7798 \$1 rppd w=0.5u l=0.5u ps=0u b=0 m=1
R$499 \$7727 \$7799 \$1 rppd w=0.5u l=0.5u ps=0u b=0 m=1
R$500 \$7728 \$7800 \$1 rppd w=0.5u l=0.5u ps=0u b=0 m=1
R$501 \$7729 \$7801 \$1 rppd w=0.5u l=0.5u ps=0u b=0 m=1
R$502 \$7730 \$7802 \$1 rppd w=0.5u l=0.5u ps=0u b=0 m=1
R$503 \$7731 \$7803 \$1 rppd w=0.5u l=0.5u ps=0u b=0 m=1
R$504 \$7732 \$7804 \$1 rppd w=0.5u l=0.5u ps=0u b=0 m=1
R$505 \$7733 \$7805 \$1 rppd w=0.5u l=0.5u ps=0u b=0 m=1
R$506 \$7734 \$7806 \$1 rppd w=0.5u l=0.5u ps=0u b=0 m=1
R$507 \$7735 \$7807 \$1 rppd w=0.5u l=0.5u ps=0u b=0 m=1
R$508 \$7736 \$7808 \$1 rppd w=0.5u l=0.5u ps=0u b=0 m=1
R$509 \$7737 \$7809 \$1 rppd w=0.5u l=0.5u ps=0u b=0 m=1
R$510 \$7738 \$7810 \$1 rppd w=0.5u l=0.5u ps=0u b=0 m=1
R$511 \$7739 \$7811 \$1 rppd w=0.5u l=0.5u ps=0u b=0 m=1
R$512 \$7740 \$7812 \$1 rppd w=0.5u l=0.5u ps=0u b=0 m=1
R$513 \$7741 \$7813 \$1 rppd w=0.5u l=0.5u ps=0u b=0 m=1
R$514 \$7742 \$7814 \$1 rppd w=0.5u l=0.5u ps=0u b=0 m=1
C$515 \$1244 \$1243 cap_cmim w=6.99u l=6.99u A=48.8601p P=27.96u m=1
C$516 \$2807 \$2806 cap_cmim w=6.99u l=6.99u A=48.8601p P=27.96u m=1
C$517 \$1248 \$1247 cap_cmim w=6.99u l=6.99u A=48.8601p P=27.96u m=1
C$518 \$1250 \$1249 cap_cmim w=6.99u l=6.99u A=48.8601p P=27.96u m=1
C$519 \$1252 \$1251 cap_cmim w=6.99u l=6.99u A=48.8601p P=27.96u m=1
C$520 \$6658 \$6657 cap_cmim w=6.99u l=6.99u A=48.8601p P=27.96u m=1
C$521 \$6660 \$6659 cap_cmim w=6.99u l=6.99u A=48.8601p P=27.96u m=1
C$522 \$1254 \$1253 cap_cmim w=6.99u l=6.99u A=48.8601p P=27.96u m=1
C$523 \$1246 \$1245 cap_cmim w=6.99u l=6.99u A=48.8601p P=27.96u m=1
C$524 \$2817 \$2816 cap_cmim w=6.99u l=6.99u A=48.8601p P=27.96u m=1
C$525 \$4798 \$4796 cap_cmim w=6.99u l=6.99u A=48.8601p P=27.96u m=1
C$526 \$2813 \$2812 cap_cmim w=6.99u l=6.99u A=48.8601p P=27.96u m=1
C$527 \$2811 \$2810 cap_cmim w=6.99u l=6.99u A=48.8601p P=27.96u m=1
C$528 \$2815 \$2814 cap_cmim w=6.99u l=6.99u A=48.8601p P=27.96u m=1
C$529 \$3174 \$3167 cap_cmim w=6.99u l=6.99u A=48.8601p P=27.96u m=1
C$530 \$2809 \$2808 cap_cmim w=6.99u l=6.99u A=48.8601p P=27.96u m=1
C$531 \$4799 \$4797 cap_cmim w=6.99u l=6.99u A=48.8601p P=27.96u m=1
C$532 G1 W G1|G2 \$1 sg13_hv_svaricap w=3.74u l=0.3u Nx=1
C$533 G1|G2 W$1 G1|G2 \$1 sg13_hv_svaricap w=3.74u l=0.3u Nx=1
.ENDS PHASED_ARRAY_77G_XTOR
