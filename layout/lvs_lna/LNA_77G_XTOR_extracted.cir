* Extracted by KLayout with SG13G2 LVS runset on : 23/07/2026 10:47

.SUBCKT RXAMP_77GD
Q$1 \$34 \$28 \$38 \$1 npn13G2l we=70n le=1000n Nx=1 m=4
Q$2 \$35 \$29 \$38 \$1 npn13G2l we=70n le=1000n Nx=1 m=4
Q$9 \$80 \$72 \$34 \$1 npn13G2l we=70n le=1000n Nx=1 m=4
Q$10 \$81 \$72 \$35 \$1 npn13G2l we=70n le=1000n Nx=1 m=4
R$17 \$9 \$8 \$1 rppd w=0.5u l=0.5u ps=0u b=0 m=1
C$18 \$18 \$17 cap_cmim w=6.99u l=6.99u A=48.8601p P=27.96u m=1
C$19 \$18 \$19 cap_cmim w=6.99u l=6.99u A=48.8601p P=27.96u m=1
.ENDS RXAMP_77GD
