* Parasitic extraction for VCO_77G_XTOR
* Total wire resistance: 37.128 Ohm
* Total wire capacitance: 87.05 fF
* Extraction method: 2D parallel-plate + fringing

.SUBCKT VCO_77G_XTOR_parasitic
Rp0 n0a n0b 0.1890 $ TM2 (106.1,240.0)-(111.1,375.0)
Cp0 n0a 0 2.5386f $ TM2 (106.1,240.0)-(111.1,375.0)
Rp1 n1a n1b 0.0117 $ TM2 (86.1,240.0)-(101.1,265.0)
Cp1 n1a 0 1.2971f $ TM2 (86.1,240.0)-(101.1,265.0)
Rp2 n2a n2b 0.0117 $ TM2 (116.1,240.0)-(131.1,265.0)
Cp2 n2a 0 1.2971f $ TM2 (116.1,240.0)-(131.1,265.0)
Rp3 n3a n3b 0.0117 $ TM2 (86.1,268.0)-(101.1,293.0)
Cp3 n3a 0 1.2971f $ TM2 (86.1,268.0)-(101.1,293.0)
Rp4 n4a n4b 0.0117 $ TM2 (116.1,268.0)-(131.1,293.0)
Cp4 n4a 0 1.2971f $ TM2 (116.1,268.0)-(131.1,293.0)
Rp5 n5a n5b 0.0117 $ TM2 (86.1,296.0)-(101.1,321.0)
Cp5 n5a 0 1.2971f $ TM2 (86.1,296.0)-(101.1,321.0)
Rp6 n6a n6b 0.0117 $ TM2 (116.1,296.0)-(131.1,321.0)
Cp6 n6a 0 1.2971f $ TM2 (116.1,296.0)-(131.1,321.0)
Rp7 n7a n7b 0.0117 $ TM2 (86.1,324.0)-(101.1,349.0)
Cp7 n7a 0 1.2971f $ TM2 (86.1,324.0)-(101.1,349.0)
Rp8 n8a n8b 0.0117 $ TM2 (116.1,324.0)-(131.1,349.0)
Cp8 n8a 0 1.2971f $ TM2 (116.1,324.0)-(131.1,349.0)
Rp9 n9a n9b 0.0107 $ TM2 (86.1,352.0)-(101.1,375.0)
Cp9 n9a 0 1.1969f $ TM2 (86.1,352.0)-(101.1,375.0)
Rp10 n10a n10b 0.0107 $ TM2 (116.1,352.0)-(131.1,375.0)
Cp10 n10a 0 1.1969f $ TM2 (116.1,352.0)-(131.1,375.0)
Rp11 n11a n11b 0.1890 $ TM2 (138.9,240.0)-(143.9,375.0)
Cp11 n11a 0 2.5386f $ TM2 (138.9,240.0)-(143.9,375.0)
Rp12 n12a n12b 0.0117 $ TM2 (118.9,240.0)-(133.9,265.0)
Cp12 n12a 0 1.2971f $ TM2 (118.9,240.0)-(133.9,265.0)
Rp13 n13a n13b 0.0117 $ TM2 (148.9,240.0)-(163.9,265.0)
Cp13 n13a 0 1.2971f $ TM2 (148.9,240.0)-(163.9,265.0)
Rp14 n14a n14b 0.0117 $ TM2 (118.9,268.0)-(133.9,293.0)
Cp14 n14a 0 1.2971f $ TM2 (118.9,268.0)-(133.9,293.0)
Rp15 n15a n15b 0.0117 $ TM2 (148.9,268.0)-(163.9,293.0)
Cp15 n15a 0 1.2971f $ TM2 (148.9,268.0)-(163.9,293.0)
Rp16 n16a n16b 0.0117 $ TM2 (118.9,296.0)-(133.9,321.0)
Cp16 n16a 0 1.2971f $ TM2 (118.9,296.0)-(133.9,321.0)
Rp17 n17a n17b 0.0117 $ TM2 (148.9,296.0)-(163.9,321.0)
Cp17 n17a 0 1.2971f $ TM2 (148.9,296.0)-(163.9,321.0)
Rp18 n18a n18b 0.0117 $ TM2 (118.9,324.0)-(133.9,349.0)
Cp18 n18a 0 1.2971f $ TM2 (118.9,324.0)-(133.9,349.0)
Rp19 n19a n19b 0.0117 $ TM2 (148.9,324.0)-(163.9,349.0)
Cp19 n19a 0 1.2971f $ TM2 (148.9,324.0)-(163.9,349.0)
Rp20 n20a n20b 0.0107 $ TM2 (118.9,352.0)-(133.9,375.0)
Cp20 n20a 0 1.1969f $ TM2 (118.9,352.0)-(133.9,375.0)
Rp21 n21a n21b 0.0107 $ TM2 (148.9,352.0)-(163.9,375.0)
Cp21 n21a 0 1.1969f $ TM2 (148.9,352.0)-(163.9,375.0)
Rp22 n22a n22b 0.1470 $ TM2 (106.1,105.0)-(111.1,210.0)
Cp22 n22a 0 1.9778f $ TM2 (106.1,105.0)-(111.1,210.0)
Rp23 n23a n23b 0.0117 $ TM2 (86.1,185.0)-(101.1,210.0)
Cp23 n23a 0 1.2971f $ TM2 (86.1,185.0)-(101.1,210.0)
Rp24 n24a n24b 0.0117 $ TM2 (116.1,185.0)-(131.1,210.0)
Cp24 n24a 0 1.2971f $ TM2 (116.1,185.0)-(131.1,210.0)
Rp25 n25a n25b 0.0117 $ TM2 (86.1,157.0)-(101.1,182.0)
Cp25 n25a 0 1.2971f $ TM2 (86.1,157.0)-(101.1,182.0)
Rp26 n26a n26b 0.0117 $ TM2 (116.1,157.0)-(131.1,182.0)
Cp26 n26a 0 1.2971f $ TM2 (116.1,157.0)-(131.1,182.0)
Rp27 n27a n27b 0.0117 $ TM2 (86.1,129.0)-(101.1,154.0)
Cp27 n27a 0 1.2971f $ TM2 (86.1,129.0)-(101.1,154.0)
Rp28 n28a n28b 0.0117 $ TM2 (116.1,129.0)-(131.1,154.0)
Cp28 n28a 0 1.2971f $ TM2 (116.1,129.0)-(131.1,154.0)
Rp29 n29a n29b 0.0098 $ TM2 (86.1,105.0)-(101.1,126.0)
Cp29 n29a 0 1.0967f $ TM2 (86.1,105.0)-(101.1,126.0)
Rp30 n30a n30b 0.0098 $ TM2 (116.1,105.0)-(131.1,126.0)
Cp30 n30a 0 1.0967f $ TM2 (116.1,105.0)-(131.1,126.0)
Rp31 n31a n31b 0.1470 $ TM2 (138.9,105.0)-(143.9,210.0)
Cp31 n31a 0 1.9778f $ TM2 (138.9,105.0)-(143.9,210.0)
Rp32 n32a n32b 0.0117 $ TM2 (118.9,185.0)-(133.9,210.0)
Cp32 n32a 0 1.2971f $ TM2 (118.9,185.0)-(133.9,210.0)
Rp33 n33a n33b 0.0117 $ TM2 (148.9,185.0)-(163.9,210.0)
Cp33 n33a 0 1.2971f $ TM2 (148.9,185.0)-(163.9,210.0)
Rp34 n34a n34b 0.0117 $ TM2 (118.9,157.0)-(133.9,182.0)
Cp34 n34a 0 1.2971f $ TM2 (118.9,157.0)-(133.9,182.0)
Rp35 n35a n35b 0.0117 $ TM2 (148.9,157.0)-(163.9,182.0)
Cp35 n35a 0 1.2971f $ TM2 (148.9,157.0)-(163.9,182.0)
Rp36 n36a n36b 0.0117 $ TM2 (118.9,129.0)-(133.9,154.0)
Cp36 n36a 0 1.2971f $ TM2 (118.9,129.0)-(133.9,154.0)
Rp37 n37a n37b 0.0117 $ TM2 (148.9,129.0)-(163.9,154.0)
Cp37 n37a 0 1.2971f $ TM2 (148.9,129.0)-(163.9,154.0)
Rp38 n38a n38b 0.0098 $ TM2 (118.9,105.0)-(133.9,126.0)
Cp38 n38a 0 1.0967f $ TM2 (118.9,105.0)-(133.9,126.0)
Rp39 n39a n39b 0.0098 $ TM2 (148.9,105.0)-(163.9,126.0)
Cp39 n39a 0 1.0967f $ TM2 (148.9,105.0)-(163.9,126.0)
Rp40 n40a n40b 0.0070 $ TM2 (106.1,237.5)-(111.1,242.5)
Cp40 n40a 0 0.1085f $ TM2 (106.1,237.5)-(111.1,242.5)
Rp41 n41a n41b 0.0070 $ TM2 (138.9,237.5)-(143.9,242.5)
Cp41 n41a 0 0.1085f $ TM2 (138.9,237.5)-(143.9,242.5)
Rp42 n42a n42b 0.0100 $ TM1 (106.1,237.5)-(111.1,242.5)
Cp42 n42a 0 0.1274f $ TM1 (106.1,237.5)-(111.1,242.5)
Rp43 n43a n43b 0.0100 $ TM1 (106.1,237.5)-(111.1,242.5)
Cp43 n43a 0 0.1274f $ TM1 (106.1,237.5)-(111.1,242.5)
Rp44 n44a n44b 0.0100 $ TM1 (138.9,237.5)-(143.9,242.5)
Cp44 n44a 0 0.1274f $ TM1 (138.9,237.5)-(143.9,242.5)
Rp45 n45a n45b 0.0100 $ TM1 (138.9,237.5)-(143.9,242.5)
Cp45 n45a 0 0.1274f $ TM1 (138.9,237.5)-(143.9,242.5)
Rp46 n46a n46b 0.0100 $ TM1 (121.2,170.3)-(127.5,176.6)
Cp46 n46a 0 0.1938f $ TM1 (121.2,170.3)-(127.5,176.6)
Rp47 n47a n47b 0.0500 $ M5 (108.4,239.8)-(108.9,240.2)
Cp47 n47a 0 0.0024f $ M5 (108.4,239.8)-(108.9,240.2)
Rp48 n48a n48b 0.0500 $ M5 (106.1,237.5)-(111.1,242.5)
Cp48 n48a 0 0.1658f $ M5 (106.1,237.5)-(111.1,242.5)
Rp49 n49a n49b 0.0500 $ M5 (141.2,239.8)-(141.7,240.2)
Cp49 n49a 0 0.0024f $ M5 (141.2,239.8)-(141.7,240.2)
Rp50 n50a n50b 0.0500 $ M5 (138.9,237.5)-(143.9,242.5)
Cp50 n50a 0 0.1658f $ M5 (138.9,237.5)-(143.9,242.5)
Rp51 n51a n51b 0.0500 $ M5 (120.3,169.4)-(128.5,177.6)
Cp51 n51a 0 0.4355f $ M5 (120.3,169.4)-(128.5,177.6)
Rp52 n52a n52b 0.0700 $ M4 (108.4,239.8)-(108.9,240.2)
Cp52 n52a 0 0.0028f $ M4 (108.4,239.8)-(108.9,240.2)
Rp53 n53a n53b 0.0700 $ M4 (108.4,239.8)-(108.9,240.2)
Cp53 n53a 0 0.0028f $ M4 (108.4,239.8)-(108.9,240.2)
Rp54 n54a n54b 0.0700 $ M4 (141.2,239.8)-(141.7,240.2)
Cp54 n54a 0 0.0028f $ M4 (141.2,239.8)-(141.7,240.2)
Rp55 n55a n55b 0.0700 $ M4 (141.2,239.8)-(141.7,240.2)
Cp55 n55a 0 0.0028f $ M4 (141.2,239.8)-(141.7,240.2)
Rp56 n56a n56b 0.0700 $ M3 (108.4,239.8)-(108.9,240.2)
Cp56 n56a 0 0.0036f $ M3 (108.4,239.8)-(108.9,240.2)
Rp57 n57a n57b 0.0700 $ M3 (108.4,239.8)-(108.9,240.2)
Cp57 n57a 0 0.0036f $ M3 (108.4,239.8)-(108.9,240.2)
Rp58 n58a n58b 0.0700 $ M3 (141.2,239.8)-(141.7,240.2)
Cp58 n58a 0 0.0036f $ M3 (141.2,239.8)-(141.7,240.2)
Rp59 n59a n59b 0.0700 $ M3 (141.2,239.8)-(141.7,240.2)
Cp59 n59a 0 0.0036f $ M3 (141.2,239.8)-(141.7,240.2)
Rp60 n60a n60b 2.6833 $ M3 (10.0,102.0)-(240.0,108.0)
Cp60 n60a 0 13.8817f $ M3 (10.0,102.0)-(240.0,108.0)
Rp61 n61a n61b 2.5900 $ M3 (122.5,245.0)-(127.5,430.0)
Cp61 n61a 0 9.3407f $ M3 (122.5,245.0)-(127.5,430.0)
Rp62 n62a n62b 0.0700 $ M2 (108.4,239.8)-(108.9,240.2)
Cp62 n62a 0 0.0050f $ M2 (108.4,239.8)-(108.9,240.2)
Rp63 n63a n63b 0.0700 $ M2 (108.4,239.8)-(108.9,240.2)
Cp63 n63a 0 0.0050f $ M2 (108.4,239.8)-(108.9,240.2)
Rp64 n64a n64b 0.0700 $ M2 (141.2,239.8)-(141.7,240.2)
Cp64 n64a 0 0.0050f $ M2 (141.2,239.8)-(141.7,240.2)
Rp65 n65a n65b 0.0700 $ M2 (141.2,239.8)-(141.7,240.2)
Cp65 n65a 0 0.0050f $ M2 (141.2,239.8)-(141.7,240.2)
Rp66 n66a n66b 1.1830 $ M2 (107.7,227.0)-(141.5,229.0)
Cp66 n66a 0 0.9904f $ M2 (107.7,227.0)-(141.5,229.0)
Rp67 n67a n67b 1.1130 $ M2 (108.7,221.0)-(140.5,223.0)
Cp67 n67a 0 0.9320f $ M2 (108.7,221.0)-(140.5,223.0)
Rp68 n68a n68b 0.1400 $ M2 (107.2,224.3)-(110.0,225.7)
Cp68 n68a 0 0.0608f $ M2 (107.2,224.3)-(110.0,225.7)
Rp69 n69a n69b 0.1400 $ M2 (107.2,212.3)-(110.0,213.7)
Cp69 n69a 0 0.0608f $ M2 (107.2,212.3)-(110.0,213.7)
Rp70 n70a n70b 0.1400 $ M2 (140.0,224.3)-(142.8,225.7)
Cp70 n70a 0 0.0608f $ M2 (140.0,224.3)-(142.8,225.7)
Rp71 n71a n71b 0.1400 $ M2 (140.0,212.3)-(142.8,213.7)
Cp71 n71a 0 0.0608f $ M2 (140.0,212.3)-(142.8,213.7)
Rp72 n72a n72b 0.0700 $ M1 (108.4,239.8)-(108.9,240.2)
Cp72 n72a 0 0.0084f $ M1 (108.4,239.8)-(108.9,240.2)
Rp73 n73a n73b 0.0700 $ M1 (141.2,239.8)-(141.7,240.2)
Cp73 n73a 0 0.0084f $ M1 (141.2,239.8)-(141.7,240.2)
Rp74 n74a n74b 0.5152 $ M1 (106.7,200.0)-(143.5,205.0)
Cp74 n74a 0 4.3460f $ M1 (106.7,200.0)-(143.5,205.0)
Rp75 n75a n75b 0.3769 $ M1 (108.5,224.3)-(108.7,225.7)
Cp75 n75a 0 0.0128f $ M1 (108.5,224.3)-(108.7,225.7)
Rp76 n76a n76b 0.1109 $ M1 (108.1,222.8)-(109.1,223.5)
Cp76 n76a 0 0.0198f $ M1 (108.1,222.8)-(109.1,223.5)
Rp77 n77a n77b 0.9975 $ M1 (109.0,223.5)-(109.1,225.8)
Cp77 n77a 0 0.0148f $ M1 (109.0,223.5)-(109.1,225.8)
Rp78 n78a n78b 0.9975 $ M1 (108.1,223.5)-(108.2,225.8)
Cp78 n78a 0 0.0148f $ M1 (108.1,223.5)-(108.2,225.8)
Rp79 n79a n79b 0.3015 $ M1 (107.2,226.5)-(110.0,227.2)
Cp79 n79a 0 0.0510f $ M1 (107.2,226.5)-(110.0,227.2)
Rp80 n80a n80b 0.4092 $ M1 (109.6,224.2)-(110.0,226.5)
Cp80 n80a 0 0.0275f $ M1 (109.6,224.2)-(110.0,226.5)
Rp81 n81a n81b 0.4092 $ M1 (107.2,224.2)-(107.6,226.5)
Cp81 n81a 0 0.0275f $ M1 (107.2,224.2)-(107.6,226.5)
Rp82 n82a n82b 0.3769 $ M1 (108.5,212.3)-(108.7,213.7)
Cp82 n82a 0 0.0128f $ M1 (108.5,212.3)-(108.7,213.7)
Rp83 n83a n83b 0.1109 $ M1 (108.1,210.8)-(109.1,211.5)
Cp83 n83a 0 0.0198f $ M1 (108.1,210.8)-(109.1,211.5)
Rp84 n84a n84b 0.9975 $ M1 (109.0,211.5)-(109.1,213.8)
Cp84 n84a 0 0.0148f $ M1 (109.0,211.5)-(109.1,213.8)
Rp85 n85a n85b 0.9975 $ M1 (108.1,211.5)-(108.2,213.8)
Cp85 n85a 0 0.0148f $ M1 (108.1,211.5)-(108.2,213.8)
Rp86 n86a n86b 0.3015 $ M1 (107.2,214.5)-(110.0,215.2)
Cp86 n86a 0 0.0510f $ M1 (107.2,214.5)-(110.0,215.2)
Rp87 n87a n87b 0.4092 $ M1 (109.6,212.2)-(110.0,214.5)
Cp87 n87a 0 0.0275f $ M1 (109.6,212.2)-(110.0,214.5)
Rp88 n88a n88b 0.4092 $ M1 (107.2,212.2)-(107.6,214.5)
Cp88 n88a 0 0.0275f $ M1 (107.2,212.2)-(107.6,214.5)
Rp89 n89a n89b 0.3769 $ M1 (141.3,224.3)-(141.5,225.7)
Cp89 n89a 0 0.0128f $ M1 (141.3,224.3)-(141.5,225.7)
Rp90 n90a n90b 0.1109 $ M1 (140.9,222.8)-(141.9,223.5)
Cp90 n90a 0 0.0198f $ M1 (140.9,222.8)-(141.9,223.5)
Rp91 n91a n91b 0.9975 $ M1 (141.8,223.5)-(141.9,225.8)
Cp91 n91a 0 0.0148f $ M1 (141.8,223.5)-(141.9,225.8)
Rp92 n92a n92b 0.9975 $ M1 (140.9,223.5)-(141.0,225.8)
Cp92 n92a 0 0.0148f $ M1 (140.9,223.5)-(141.0,225.8)
Rp93 n93a n93b 0.3015 $ M1 (140.0,226.5)-(142.8,227.2)
Cp93 n93a 0 0.0510f $ M1 (140.0,226.5)-(142.8,227.2)
Rp94 n94a n94b 0.4092 $ M1 (142.4,224.2)-(142.8,226.5)
Cp94 n94a 0 0.0275f $ M1 (142.4,224.2)-(142.8,226.5)
Rp95 n95a n95b 0.4092 $ M1 (140.0,224.2)-(140.4,226.5)
Cp95 n95a 0 0.0275f $ M1 (140.0,224.2)-(140.4,226.5)
Rp96 n96a n96b 0.3769 $ M1 (141.3,212.3)-(141.5,213.7)
Cp96 n96a 0 0.0128f $ M1 (141.3,212.3)-(141.5,213.7)
Rp97 n97a n97b 0.1109 $ M1 (140.9,210.8)-(141.9,211.5)
Cp97 n97a 0 0.0198f $ M1 (140.9,210.8)-(141.9,211.5)
Rp98 n98a n98b 0.9975 $ M1 (141.8,211.5)-(141.9,213.8)
Cp98 n98a 0 0.0148f $ M1 (141.8,211.5)-(141.9,213.8)
Rp99 n99a n99b 0.9975 $ M1 (140.9,211.5)-(141.0,213.8)
Cp99 n99a 0 0.0148f $ M1 (140.9,211.5)-(141.0,213.8)
Rp100 n100a n100b 0.3015 $ M1 (140.0,214.5)-(142.8,215.2)
Cp100 n100a 0 0.0510f $ M1 (140.0,214.5)-(142.8,215.2)
Rp101 n101a n101b 0.4092 $ M1 (142.4,212.2)-(142.8,214.5)
Cp101 n101a 0 0.0275f $ M1 (142.4,212.2)-(142.8,214.5)
Rp102 n102a n102b 0.4092 $ M1 (140.0,212.2)-(140.4,214.5)
Cp102 n102a 0 0.0275f $ M1 (140.0,212.2)-(140.4,214.5)
Rp103 n103a n103b 0.3290 $ M1 (105.3,246.9)-(105.5,247.9)
Cp103 n103a 0 0.0073f $ M1 (105.3,246.9)-(105.5,247.9)
Rp104 n104a n104b 0.3290 $ M1 (105.3,246.9)-(105.5,247.9)
Cp104 n104a 0 0.0073f $ M1 (105.3,246.9)-(105.5,247.9)
Rp105 n105a n105b 0.2181 $ M1 (105.8,249.5)-(106.6,249.8)
Cp105 n105a 0 0.0077f $ M1 (105.8,249.5)-(106.6,249.8)
Rp106 n106a n106b 0.2181 $ M1 (105.8,249.5)-(106.6,249.8)
Cp106 n106a 0 0.0077f $ M1 (105.8,249.5)-(106.6,249.8)
Rp107 n107a n107b 0.2181 $ M1 (105.8,245.0)-(106.6,245.3)
Cp107 n107a 0 0.0077f $ M1 (105.8,245.0)-(106.6,245.3)
Rp108 n108a n108b 0.2181 $ M1 (105.8,245.0)-(106.6,245.3)
Cp108 n108a 0 0.0077f $ M1 (105.8,245.0)-(106.6,245.3)
Rp109 n109a n109b 0.1400 $ M1 (106.3,245.3)-(106.6,245.4)
Cp109 n109a 0 0.0018f $ M1 (106.3,245.3)-(106.6,245.4)
Rp110 n110a n110b 0.1400 $ M1 (105.8,249.4)-(106.0,249.5)
Cp110 n110a 0 0.0018f $ M1 (105.8,249.4)-(106.0,249.5)
Rp111 n111a n111b 0.9827 $ M1 (106.3,245.4)-(106.6,249.1)
Cp111 n111a 0 0.0322f $ M1 (106.3,245.4)-(106.6,249.1)
Rp112 n112a n112b 0.9827 $ M1 (106.3,245.4)-(106.6,249.1)
Cp112 n112a 0 0.0322f $ M1 (106.3,245.4)-(106.6,249.1)
Rp113 n113a n113b 0.9827 $ M1 (105.8,245.7)-(106.0,249.4)
Cp113 n113a 0 0.0322f $ M1 (105.8,245.7)-(106.0,249.4)
Rp114 n114a n114b 0.9827 $ M1 (105.8,245.7)-(106.0,249.4)
Cp114 n114a 0 0.0322f $ M1 (105.8,245.7)-(106.0,249.4)
Rp115 n115a n115b 0.3290 $ M1 (140.3,246.9)-(140.5,247.9)
Cp115 n115a 0 0.0073f $ M1 (140.3,246.9)-(140.5,247.9)
Rp116 n116a n116b 0.3290 $ M1 (140.3,246.9)-(140.5,247.9)
Cp116 n116a 0 0.0073f $ M1 (140.3,246.9)-(140.5,247.9)
Rp117 n117a n117b 0.2181 $ M1 (140.8,249.5)-(141.6,249.8)
Cp117 n117a 0 0.0077f $ M1 (140.8,249.5)-(141.6,249.8)
Rp118 n118a n118b 0.2181 $ M1 (140.8,249.5)-(141.6,249.8)
Cp118 n118a 0 0.0077f $ M1 (140.8,249.5)-(141.6,249.8)
Rp119 n119a n119b 0.2181 $ M1 (140.8,245.0)-(141.6,245.3)
Cp119 n119a 0 0.0077f $ M1 (140.8,245.0)-(141.6,245.3)
Rp120 n120a n120b 0.2181 $ M1 (140.8,245.0)-(141.6,245.3)
Cp120 n120a 0 0.0077f $ M1 (140.8,245.0)-(141.6,245.3)
Rp121 n121a n121b 0.1400 $ M1 (141.3,245.3)-(141.6,245.4)
Cp121 n121a 0 0.0018f $ M1 (141.3,245.3)-(141.6,245.4)
Rp122 n122a n122b 0.1400 $ M1 (140.8,249.4)-(141.0,249.5)
Cp122 n122a 0 0.0018f $ M1 (140.8,249.4)-(141.0,249.5)
Rp123 n123a n123b 0.9827 $ M1 (141.3,245.4)-(141.6,249.1)
Cp123 n123a 0 0.0322f $ M1 (141.3,245.4)-(141.6,249.1)
Rp124 n124a n124b 0.9827 $ M1 (141.3,245.4)-(141.6,249.1)
Cp124 n124a 0 0.0322f $ M1 (141.3,245.4)-(141.6,249.1)
Rp125 n125a n125b 0.9827 $ M1 (140.8,245.7)-(141.0,249.4)
Cp125 n125a 0 0.0322f $ M1 (140.8,245.7)-(141.0,249.4)
Rp126 n126a n126b 0.9827 $ M1 (140.8,245.7)-(141.0,249.4)
Cp126 n126a 0 0.0322f $ M1 (140.8,245.7)-(141.0,249.4)
Rp127 n127a n127b 0.1073 $ M1 (124.6,195.6)-(125.0,195.9)
Cp127 n127a 0 0.0052f $ M1 (124.6,195.6)-(125.0,195.9)
Rp128 n128a n128b 0.1073 $ M1 (124.6,194.6)-(125.0,194.9)
Cp128 n128a 0 0.0052f $ M1 (124.6,194.6)-(125.0,194.9)
.ENDS
