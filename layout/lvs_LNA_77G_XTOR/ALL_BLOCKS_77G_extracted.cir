* Extracted by KLayout with SG13G2 LVS runset on : 24/07/2026 09:42

.SUBCKT LNA_77G_XTOR
Q$1 \$21 \$20 \$26 \$1 npn13G2l we=70n le=1000n Nx=1 m=4
Q$2 \$22 \$23 \$27 \$1 npn13G2l we=70n le=1000n Nx=1 m=4
Q$9 \$67 \$62 \$21 \$1 npn13G2l we=70n le=1000n Nx=1 m=4
Q$10 \$68 \$62 \$22 \$1 npn13G2l we=70n le=1000n Nx=1 m=4
R$17 \$104 \$105 \$1 rppd w=0.5u l=0.5u ps=0u b=0 m=1
C$18 \$111 \$110 cap_cmim w=6.99u l=6.99u A=48.8601p P=27.96u m=1
C$19 \$113 \$112 cap_cmim w=6.99u l=6.99u A=48.8601p P=27.96u m=1
.ENDS LNA_77G_XTOR
