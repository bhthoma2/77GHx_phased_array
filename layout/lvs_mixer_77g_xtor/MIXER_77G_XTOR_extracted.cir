* Extracted by KLayout with SG13G2 LVS runset on : 15/07/2026 13:52

.SUBCKT MIXER_77G_XTOR
Q$1 \$31 \$32 \$37 \$1 npn13G2l we=70n le=1000n Nx=1 m=1
Q$2 \$33 \$34 \$38 \$1 npn13G2l we=70n le=1000n Nx=1 m=1
Q$3 \$39 \$40 \$53 \$1 npn13G2l we=70n le=1000n Nx=1 m=1
Q$4 \$41 \$42 \$54 \$1 npn13G2l we=70n le=1000n Nx=1 m=1
Q$5 \$55 \$56 \$69 \$1 npn13G2l we=70n le=1000n Nx=1 m=1
Q$6 \$57 \$58 \$70 \$1 npn13G2l we=70n le=1000n Nx=1 m=1
Q$7 \$71 \$72 \$85 \$1 npn13G2l we=70n le=1000n Nx=1 m=1
Q$8 \$73 \$74 \$86 \$1 npn13G2l we=70n le=1000n Nx=1 m=1
Q$9 \$99 \$100 \$111 \$1 npn13G2l we=70n le=1000n Nx=1 m=1
Q$10 \$101 \$102 \$112 \$1 npn13G2l we=70n le=1000n Nx=1 m=1
Q$11 \$103 \$104 \$113 \$1 npn13G2l we=70n le=1000n Nx=1 m=1
Q$12 \$105 \$106 \$114 \$1 npn13G2l we=70n le=1000n Nx=1 m=1
Q$13 \$115 \$116 \$143 \$1 npn13G2l we=70n le=1000n Nx=1 m=1
Q$14 \$117 \$118 \$144 \$1 npn13G2l we=70n le=1000n Nx=1 m=1
Q$15 \$119 \$120 \$145 \$1 npn13G2l we=70n le=1000n Nx=1 m=1
Q$16 \$121 \$122 \$146 \$1 npn13G2l we=70n le=1000n Nx=1 m=1
R$17 \$18 \$19 \$1 rppd w=0.5u l=0.5u ps=0u b=0 m=1
R$18 \$149 \$148 \$1 rppd w=0.5u l=0.5u ps=0u b=0 m=1
R$19 \$151 \$150 \$1 rppd w=0.5u l=0.5u ps=0u b=0 m=1
.ENDS MIXER_77G_XTOR
