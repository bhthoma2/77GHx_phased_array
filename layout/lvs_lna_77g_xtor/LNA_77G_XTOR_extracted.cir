* Extracted by KLayout with SG13G2 LVS runset on : 15/07/2026 13:52

.SUBCKT LNA_77G_XTOR
Q$1 \$20 \$21 \$26 \$1 npn13G2l we=70n le=1000n Nx=1 m=1
Q$2 \$22 \$23 \$27 \$1 npn13G2l we=70n le=1000n Nx=1 m=1
Q$3 \$28 \$29 \$42 \$1 npn13G2l we=70n le=1000n Nx=1 m=1
Q$4 \$30 \$31 \$43 \$1 npn13G2l we=70n le=1000n Nx=1 m=1
Q$5 \$44 \$45 \$58 \$1 npn13G2l we=70n le=1000n Nx=1 m=1
Q$6 \$46 \$47 \$59 \$1 npn13G2l we=70n le=1000n Nx=1 m=1
Q$7 \$60 \$61 \$74 \$1 npn13G2l we=70n le=1000n Nx=1 m=1
Q$8 \$62 \$63 \$75 \$1 npn13G2l we=70n le=1000n Nx=1 m=1
Q$9 \$76 \$77 \$90 \$1 npn13G2l we=70n le=1000n Nx=1 m=1
Q$10 \$78 \$79 \$91 \$1 npn13G2l we=70n le=1000n Nx=1 m=1
Q$11 \$92 \$93 \$106 \$1 npn13G2l we=70n le=1000n Nx=1 m=1
Q$12 \$94 \$95 \$107 \$1 npn13G2l we=70n le=1000n Nx=1 m=1
Q$13 \$108 \$109 \$122 \$1 npn13G2l we=70n le=1000n Nx=1 m=1
Q$14 \$110 \$111 \$123 \$1 npn13G2l we=70n le=1000n Nx=1 m=1
Q$15 \$124 \$125 \$138 \$1 npn13G2l we=70n le=1000n Nx=1 m=1
Q$16 \$126 \$127 \$139 \$1 npn13G2l we=70n le=1000n Nx=1 m=1
R$17 \$141 \$142 \$1 rppd w=0.5u l=0.5u ps=0u b=0 m=1
C$18 \$150 \$149 cap_cmim w=6.99u l=6.99u A=48.8601p P=27.96u m=1
C$19 \$152 \$151 cap_cmim w=6.99u l=6.99u A=48.8601p P=27.96u m=1
.ENDS LNA_77G_XTOR
