* VCO 77GHz — Xyce Harmonic Balance Analysis
* Run: Xyce sim_vco_hb.cir
* Requires: Xyce built with HB support (Trilinos + LOCA)

.include /home/bthomas3/Videos/77GHz_phased_array/layout/testbenches/simulations/npn13G2l_xyce.lib

VCC vcc 0 DC 3.3
VTUNE vtune 0 DC 0.9

* Cross-coupled VCO (flat Q devices, 4-terminal: c b e s)
Q1 c1 c2 tail 0 npn13G2l_mod m=2
Q2 c2 c1 tail 0 npn13G2l_mod m=2

* LC tank (L=32pH gives ~76GHz with HBT parasitics)
L1 vcc c1_l 32p
RL1 c1_l c1 1.9
L2 vcc c2_l 32p
RL2 c2_l c2 1.9

* Tail current
ITAIL tail 0 DC 6m

* Strong injection to force large-signal oscillation in HB
* Need Iinj * Ztank > 2*VT to switch diff pair
* Ztank ≈ Q*wL = 8*2π*77G*32p = 124Ω → Iinj > 0.4mA
* Use 2mA to guarantee full switching
Iinj1 0 c1 SIN(0 2m 77e9)
Iinj2 c2 0 SIN(0 2m 77e9)

* HB: TAHB=2 (DC as initial guess) + GMIN for DC OP convergence
.OPTIONS HBINT NUMFREQ=7 TAHB=2
.OPTIONS NONLIN MAXSTEP=200 SEARCHMETHOD=2 CONTINUATION=GMIN
+ ABSTOL=1e-6 RELTOL=1e-2

.HB 77e9

.NODESET v(c1)=3.3 v(c2)=3.3 v(tail)=2.4

.PRINT HB_FD v(c1) v(c2) i(VCC)
.PRINT HB_TD v(c1) v(c2)

.END
