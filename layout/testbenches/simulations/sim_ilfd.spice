** Injection-Locked Frequency Divider (÷2) — 77 GHz → 38.5 GHz
** Based on ILFD_77G reference: cross-coupled LC osc with tail injection
.control
pre_osdi /home/bthomas3/Videos/ngspice_pdk/install/lib/ngspice/r3_cmc.osdi
pre_osdi /home/bthomas3/Videos/ngspice_pdk/install/lib/ngspice/psp103_nqs.osdi
.endc

.lib /home/bthomas3/Videos/IHP-Open-PDK/ihp-sg13g2/libs.tech/ngspice/models/cornerHBT.lib hbt_typ
.lib /home/bthomas3/Videos/IHP-Open-PDK/ihp-sg13g2/libs.tech/ngspice/models/cornerRES.lib res_typ
.lib /home/bthomas3/Videos/IHP-Open-PDK/ihp-sg13g2/libs.tech/ngspice/models/cornerCAP.lib cap_typ

** === TL 850µm resonator (Z0=85) — ~38.5 GHz ===
.subckt TL_85_850u IN OUT GND
C1 IN GND 1.538fF
R1 IN n1 1.108
L1 n1 n2 22.3pH
C2 n2 GND 3.075fF
R2 n2 n3 1.108
L2 n3 n4 22.3pH
C3 n4 GND 3.075fF
R3 n4 n5 1.108
L3 n5 n6 22.3pH
C4 n6 GND 3.075fF
R4 n6 n7 1.108
L4 n7 n8 22.3pH
C5 n8 GND 3.075fF
R5 n8 n9 1.108
L5 n9 n10 22.3pH
C6 n10 GND 3.075fF
R6 n10 n11 1.108
L6 n11 n12 22.3pH
C7 n12 GND 3.075fF
R7 n12 n13 1.108
L7 n13 n14 22.3pH
C8 n14 GND 3.075fF
R8 n14 n15 1.108
L8 n15 n16 22.3pH
C9 n16 GND 3.075fF
R9 n16 n17 1.108
L9 n17 n18 22.3pH
C10 n18 GND 3.075fF
R10 n18 n19 1.108
L10 n19 n20 22.3pH
C11 n20 GND 3.075fF
R11 n20 n21 1.108
L11 n21 n22 22.3pH
C12 n22 GND 3.075fF
R12 n22 n23 1.108
L12 n23 n24 22.3pH
C13 n24 GND 3.075fF
R13 n24 n25 1.108
L13 n25 n26 22.3pH
C14 n26 GND 3.075fF
R14 n26 n27 1.108
L14 n27 n28 22.3pH
C15 n28 GND 3.075fF
R15 n28 n29 1.108
L15 n29 n30 22.3pH
C16 n30 GND 3.075fF
R16 n30 n31 1.108
L16 n31 n32 22.3pH
C17 n32 GND 3.075fF
R17 n32 n33 1.108
L17 n33 OUT 22.3pH
C18 OUT GND 1.538fF
.ends

** === TL 250µm choke (Z0=85) ===
.subckt TL_85_250u IN OUT GND
C1 IN GND 1.538fF
R1 IN n1 1.108
L1 n1 n2 22.3pH
C2 n2 GND 3.075fF
R2 n2 n3 1.108
L2 n3 n4 22.3pH
C3 n4 GND 3.075fF
R3 n4 n5 1.108
L3 n5 n6 22.3pH
C4 n6 GND 3.075fF
R4 n6 n7 1.108
L4 n7 n8 22.3pH
C5 n8 GND 3.075fF
R5 n8 n9 1.108
L5 n9 OUT 22.3pH
C6 OUT GND 1.538fF
.ends

** === ILFD Subcircuit ===
.subckt ILFD_77G INP INN OUTP OUTN VCC VSS

** Cross-coupled pair (free-running at ~38.5 GHz)
XQ1 OUTP OUTN net_tail VSS npn13G2l Nx=2 le=2.5e-6
XQ2 OUTN OUTP net_tail VSS npn13G2l Nx=2 le=2.5e-6

** Resonator stubs tuned for ~38.5 GHz
XTLRES1 OUTP res1_end VSS TL_85_850u
XTLRES2 OUTN res2_end VSS TL_85_850u

** DC feed choke (~250µm)
XTLCHK1 VCC OUTP VSS TL_85_250u
XTLCHK2 VCC OUTN VSS TL_85_250u

** Injection transistors (77 GHz input drives tail current)
XQinj1 net_tail INP net_inj_tail VSS npn13G2l Nx=2 le=2.5e-6
XQinj2 net_tail INN net_inj_tail VSS npn13G2l Nx=2 le=2.5e-6

** Tail bias
Rtail net_inj_tail VSS 100

** Decoupling
Cdecap VCC VSS 3pF

.ends ILFD_77G

** === Testbench ===
VCC VCC 0 2.4
VB_INJ VB_INJ 0 0.92

** 77 GHz injection signal
Vinj_p inj_ac_p 0 SIN(0 250m 77G)
Vinj_n inj_ac_n 0 SIN(0 -250m 77G)
Cblk_p inj_ac_p INP 100fF
Cblk_n inj_ac_n INN 100fF
Rbias_p VB_INJ INP 10k
Rbias_n VB_INJ INN 10k

** ILFD instance
XILFD INP INN OUTP OUTN VCC 0 ILFD_77G

** Output loads
RL1 OUTP 0 200
RL2 OUTN 0 200

** Stub terminations are internal to subcircuit (open-ended by design)

** Initial conditions to kick oscillation
.ic v(outp)=2.4 v(outn)=2.0

.options reltol=5e-3 abstol=1e-9 vntol=1e-3 itl1=500 itl4=500
.options method=trap

.control
tran 0.1p 4n 1n 0.1p

** Measure output frequency (should be ~38.5 GHz)
let vdiff = v(outp) - v(outn)
meas tran t1 WHEN vdiff=0 RISE=20
meas tran t2 WHEN vdiff=0 RISE=21
let period = t2 - t1
let freq_ghz = 1e-9/period

** Measure output swing
meas tran vout_max MAX v(outp) from=3n to=4n
meas tran vout_min MIN v(outp) from=3n to=4n
let swing = vout_max - vout_min

echo ""
echo "========================================="
echo "  ILFD RESULTS — IHP SG13G2 PDK"
echo "========================================="
echo "Output period:"
print period
echo "Output frequency (GHz):"
print freq_ghz
echo "Output swing (V):"
print swing
echo "ICC:"
print @vcc[i]
echo "========================================="
quit
.endc

.end
