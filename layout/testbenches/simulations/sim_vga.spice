* VGA — Variable-gm via Programmable Tail Current
* Design methodology: gm/Id (from IHP AnalogAcademy module_0)
*
* Topology: Differential pair with variable tail current
*   - BJT gm = Ic/VT = Itail/(2*VT)
*   - Gain = gm * RL = Itail*RL/(2*VT)
*   - Itail range: 100µA to 10mA → gain range = 40dB
*   - VCTRL controls a current mirror that sets Itail
*
* This gives linear-in-dB gain control (for BJT: gain ∝ Itail ∝ exp(Vctrl))

.lib /home/bthomas3/Videos/IHP-Open-PDK/ihp-sg13g2/libs.tech/ngspice/models/cornerHBT.lib hbt_typ

.param vctrl_val = 0.85

VCC vcc 0 DC 3.3

* === GAIN CONTROL: Exponential tail current ===
* BJT as voltage-to-current converter: Ic = Is*exp(Vbe/VT)
* VCTRL directly drives base of tail transistor
* Emitter degeneration Re linearizes slightly but preserves range
XQtail tail vctrl_node etail 0 npn13G2l m=4
Retail etail 0 10
Vctrl vctrl_node 0 DC vctrl_val

* === SIGNAL PATH: Differential pair ===
XQ1 outp inp tail 0 npn13G2l
XQ2 outn inn tail 0 npn13G2l

* Load resistors (RL=500Ω gives max gain = gm*RL at Itail=10mA)
* Max gain = (10m/2)/26mV * 500 = 96 = 39.6 dB
RL1 vcc outp 500
RL2 vcc outn 500

* AC differential input (high CM for tail headroom: Vtail = 1.5-0.85 = 0.65V)
VIN_P inp 0 DC 1.5 AC 0.5
VIN_N inn 0 DC 1.5 AC -0.5

.control
echo "============================================"
echo "  VGA — Variable-gm (Programmable Itail)"
echo "  gm/Id methodology from IHP AnalogAcademy"
echo "============================================"
echo "VCTRL(V)  Gain(dB)  Itail(mA)  gm(mS)"
echo "--------------------------------------------"
foreach vval 0.65 0.70 0.75 0.80 0.85 0.90 0.95 1.00
  alterparam vctrl_val = $vval
  reset
  ac dec 10 100k 1G
  meas ac gp find vdb(outp) at=1e6
  meas ac gn find vdb(outn) at=1e6
  let gdiff = gp - gn
  echo "VCTRL=$vval  Gain_p=$&gp Gain_n=$&gn"
end
echo "============================================"
echo "Gain range target: 0-30 dB (VCTRL=0.65-0.95V)"
echo "============================================"
.endc

.end
