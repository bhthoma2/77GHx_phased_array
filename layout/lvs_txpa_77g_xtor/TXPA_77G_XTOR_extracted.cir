* Extracted by KLayout with SG13G2 LVS runset on : 15/07/2026 13:52

.SUBCKT TXPA_77G_XTOR
Q$1 \$20 \$21 \$26 \$1 npn13G2l we=70n le=1000n Nx=1 m=1
Q$2 \$22 \$23 \$27 \$1 npn13G2l we=70n le=1000n Nx=1 m=1
Q$3 \$28 \$29 \$42 \$1 npn13G2l we=70n le=1000n Nx=1 m=1
Q$4 \$30 \$31 \$43 \$1 npn13G2l we=70n le=1000n Nx=1 m=1
Q$5 \$44 \$45 \$58 \$1 npn13G2l we=70n le=1000n Nx=1 m=1
Q$6 \$46 \$47 \$59 \$1 npn13G2l we=70n le=1000n Nx=1 m=1
Q$7 \$60 \$61 \$74 \$1 npn13G2l we=70n le=1000n Nx=1 m=1
Q$8 \$62 \$63 \$75 \$1 npn13G2l we=70n le=1000n Nx=1 m=1
Q$9 \$76 \$77 \$90 \$1 npn13G2l we=70n le=1000n Nx=1 m=1
Q$10 \$78 \$79 \$91 \$1 npn13G2l we=70n le=1000n Nx=1 m=1
Q$11 \$92 \$93 \$106 \$1 npn13G2l we=70n le=1000n Nx=1 m=1
Q$12 \$94 \$95 \$107 \$1 npn13G2l we=70n le=1000n Nx=1 m=1
Q$13 \$108 \$109 \$122 \$1 npn13G2l we=70n le=1000n Nx=1 m=1
Q$14 \$110 \$111 \$123 \$1 npn13G2l we=70n le=1000n Nx=1 m=1
Q$15 \$124 \$125 \$138 \$1 npn13G2l we=70n le=1000n Nx=1 m=1
Q$16 \$126 \$127 \$139 \$1 npn13G2l we=70n le=1000n Nx=1 m=1
Q$17 \$140 \$141 \$154 \$1 npn13G2l we=70n le=1000n Nx=1 m=1
Q$18 \$142 \$143 \$155 \$1 npn13G2l we=70n le=1000n Nx=1 m=1
Q$19 \$156 \$157 \$170 \$1 npn13G2l we=70n le=1000n Nx=1 m=1
Q$20 \$158 \$159 \$171 \$1 npn13G2l we=70n le=1000n Nx=1 m=1
Q$21 \$172 \$173 \$186 \$1 npn13G2l we=70n le=1000n Nx=1 m=1
Q$22 \$174 \$175 \$187 \$1 npn13G2l we=70n le=1000n Nx=1 m=1
Q$23 \$188 \$189 \$202 \$1 npn13G2l we=70n le=1000n Nx=1 m=1
Q$24 \$190 \$191 \$203 \$1 npn13G2l we=70n le=1000n Nx=1 m=1
Q$25 \$204 \$205 \$218 \$1 npn13G2l we=70n le=1000n Nx=1 m=1
Q$26 \$206 \$207 \$219 \$1 npn13G2l we=70n le=1000n Nx=1 m=1
Q$27 \$220 \$221 \$234 \$1 npn13G2l we=70n le=1000n Nx=1 m=1
Q$28 \$222 \$223 \$235 \$1 npn13G2l we=70n le=1000n Nx=1 m=1
Q$29 \$236 \$237 \$250 \$1 npn13G2l we=70n le=1000n Nx=1 m=1
Q$30 \$238 \$239 \$251 \$1 npn13G2l we=70n le=1000n Nx=1 m=1
Q$31 \$252 \$253 \$266 \$1 npn13G2l we=70n le=1000n Nx=1 m=1
Q$32 \$254 \$255 \$267 \$1 npn13G2l we=70n le=1000n Nx=1 m=1
R$33 \$270 \$269 \$1 rppd w=0.5u l=0.5u ps=0u b=0 m=1
.ENDS TXPA_77G_XTOR
