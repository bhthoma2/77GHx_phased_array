.subckt VCO_77G_XTOR G1 G1_G2 GND VCC W W$1
XQ1 G1_G2 G1_G2 TAIL sub! npn13G2l Nx=1 m=4
XR1 GND TAIL sub! rppd w=0.5u l=0.5u m=1 b=0
XCdecap VCC GND cap_cmim w=6.99u l=6.99u
XCV1 G1 W G1_G2 sub! sg13_hv_svaricap w=3.74u l=0.3u Nx=1
XCV2 G1_G2 W$1 G1_G2 sub! sg13_hv_svaricap w=3.74u l=0.3u Nx=1
.ends VCO_77G_XTOR
